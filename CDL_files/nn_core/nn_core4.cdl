*******************************************************************************
* nn_core4.cdl — Top-level: forward4 + backward4 + gen_din_sel4 + delays
* Ref libs: gpdk090 + stdcel + your working lib (has forward4, backward4)
*******************************************************************************

*=== STD CELL STUBS ===*
.SUBCKT INVX1 A Y VDD VSS
.ENDS INVX1

.SUBCKT DFFQX1 CK D Q VDD VSS
.ENDS DFFQX1

.SUBCKT NOR2X1 A B Y VDD VSS
.ENDS NOR2X1

.SUBCKT NAND2X1 A B Y VDD VSS
.ENDS NAND2X1

.SUBCKT XNOR2X1 A B Y VDD VSS
.ENDS XNOR2X1

*=== DERIVED WRAPPERS ===*
.SUBCKT AND2X1 A B Y VDD VSS
XNAND1 A B n_ab VDD VSS / NAND2X1
XINV1 n_ab Y VDD VSS / INVX1
.ENDS AND2X1

.SUBCKT OR2X1 A B Y VDD VSS
XNOR1 A B n_ab VDD VSS / NOR2X1
XINV1 n_ab Y VDD VSS / INVX1
.ENDS OR2X1

.SUBCKT XOR2X1 A B Y VDD VSS
XXNOR1 A B n_ab VDD VSS / XNOR2X1
XINV1 n_ab Y VDD VSS / INVX1
.ENDS XOR2X1

.SUBCKT MX2X1 A B S0 Y VDD VSS
XINV_S0 S0 S0b VDD VSS / INVX1
XNA A S0b na VDD VSS / NAND2X1
XNB B S0 nb VDD VSS / NAND2X1
XOUT na nb Y VDD VSS / NAND2X1
.ENDS MX2X1

.SUBCKT CLKINVX1 A Y VDD VSS
XINV1 A Y VDD VSS / INVX1
.ENDS CLKINVX1

.SUBCKT CLKXOR2X1 A B Y VDD VSS
XXOR1 A B Y VDD VSS / XOR2X1
.ENDS CLKXOR2X1

.SUBCKT SDFFQX1 CK D SI SE Q VDD VSS
XMUX1 D SI SE net_mux VDD VSS / MX2X1
XDFF1 CK net_mux Q VDD VSS / DFFQX1
.ENDS SDFFQX1

*=== BLOCK STUBS (real schematics in working lib) ===*
.SUBCKT forward4
+ clk reset din select_initial update_coeff
+ input_k1_0 input_k1_1 input_k1_2 input_k1_3
+ input_k2_0 input_k2_1 input_k2_2 input_k2_3
+ cap_dw2_11_0 cap_dw2_11_1 cap_dw2_11_2 cap_dw2_11_3
+ cap_dw2_21_0 cap_dw2_21_1 cap_dw2_21_2 cap_dw2_21_3
+ cap_dw2_12_0 cap_dw2_12_1 cap_dw2_12_2 cap_dw2_12_3
+ cap_dw2_22_0 cap_dw2_22_1 cap_dw2_22_2 cap_dw2_22_3
+ cap_dw3_11_0 cap_dw3_11_1 cap_dw3_11_2 cap_dw3_11_3
+ cap_dw3_21_0 cap_dw3_21_1 cap_dw3_21_2 cap_dw3_21_3
+ cap_db2_1_0 cap_db2_1_1 cap_db2_1_2 cap_db2_1_3
+ cap_db2_2_0 cap_db2_2_1 cap_db2_2_2 cap_db2_2_3
+ cap_db3_1_0 cap_db3_1_1 cap_db3_1_2 cap_db3_1_3
+ w3_11_0 w3_11_1 w3_11_2 w3_11_3
+ w3_21_0 w3_21_1 w3_21_2 w3_21_3
+ a2_1_0 a2_1_1 a2_1_2 a2_1_3
+ a2_2_0 a2_2_1 a2_2_2 a2_2_3
+ a3_1_0 a3_1_1 a3_1_2 a3_1_3
+ k1_out_0 k1_out_1 k1_out_2 k1_out_3
+ k2_out_0 k2_out_1 k2_out_2 k2_out_3
+ t1_out_0 t1_out_1 t1_out_2 t1_out_3
+ finish_updating VDD VSS
.ENDS forward4

.SUBCKT backward4 clk res
+ a3_1_0 a3_1_1 a3_1_2 a3_1_3
+ a2_1_0 a2_1_1 a2_1_2 a2_1_3
+ a2_2_0 a2_2_1 a2_2_2 a2_2_3
+ k1_0 k1_1 k1_2 k1_3
+ k2_0 k2_1 k2_2 k2_3
+ t1_0 t1_1 t1_2 t1_3
+ w3_11_0 w3_11_1 w3_11_2 w3_11_3
+ w3_21_0 w3_21_1 w3_21_2 w3_21_3
+ cap_dw3_11_0 cap_dw3_11_1 cap_dw3_11_2 cap_dw3_11_3
+ cap_dw3_21_0 cap_dw3_21_1 cap_dw3_21_2 cap_dw3_21_3
+ cap_dw2_11_0 cap_dw2_11_1 cap_dw2_11_2 cap_dw2_11_3
+ cap_dw2_21_0 cap_dw2_21_1 cap_dw2_21_2 cap_dw2_21_3
+ cap_dw2_12_0 cap_dw2_12_1 cap_dw2_12_2 cap_dw2_12_3
+ cap_dw2_22_0 cap_dw2_22_1 cap_dw2_22_2 cap_dw2_22_3
+ cap_db3_1_0 cap_db3_1_1 cap_db3_1_2 cap_db3_1_3
+ cap_db2_1_0 cap_db2_1_1 cap_db2_1_2 cap_db2_1_3
+ cap_db2_2_0 cap_db2_2_1 cap_db2_2_2 cap_db2_2_3
+ VDD VSS
.ENDS backward4

*******************************************************************************
* MODULE: delay1_4_36
*******************************************************************************
.SUBCKT delay1_4_36 clk res in_0 in_1 in_2 in_3 out_0 out_1 out_2 out_3 VDD VSS
Xout_reg_0 clk n_2 out_2 VDD VSS / DFFQX1
Xg4 res n_1 n_2 VDD VSS / NOR2X1
Xg5 in_0 n_1 VDD VSS / CLKINVX1
.ENDS delay1_4_36

*******************************************************************************
* MODULE: delay1_4_37
*******************************************************************************
.SUBCKT delay1_4_37 clk res in_0 in_1 in_2 in_3 out_0 out_1 out_2 out_3 VDD VSS
Xout_reg_0 clk n_2 out_2 VDD VSS / DFFQX1
Xg4 res n_1 n_2 VDD VSS / NOR2X1
Xg5 in_0 n_1 VDD VSS / CLKINVX1
.ENDS delay1_4_37

*******************************************************************************
* MODULE: delay1_4_38
*******************************************************************************
.SUBCKT delay1_4_38 clk res in_0 in_1 in_2 in_3 out_0 out_1 out_2 out_3 VDD VSS
Xout_reg_0 clk n_2 out_2 VDD VSS / DFFQX1
Xg4 res n_1 n_2 VDD VSS / NOR2X1
Xg5 in_0 n_1 VDD VSS / CLKINVX1
.ENDS delay1_4_38

*******************************************************************************
* MODULE: delay1_4_39
*******************************************************************************
.SUBCKT delay1_4_39 clk res in_0 in_1 in_2 in_3 out_0 out_1 out_2 out_3 VDD VSS
Xout_reg_0 clk n_2 out_2 VDD VSS / DFFQX1
Xg4 res n_1 n_2 VDD VSS / NOR2X1
Xg5 in_0 n_1 VDD VSS / CLKINVX1
.ENDS delay1_4_39

*******************************************************************************
* MODULE: delay1_4_364
*******************************************************************************
.SUBCKT delay1_4_364 clk res in_0 in_1 in_2 in_3 out_0 out_1 out_2 out_3 VDD VSS
Xout_reg_3 clk n_7 out_3 VDD VSS / DFFQX1
Xout_reg_2 clk n_4 out_2 VDD VSS / DFFQX1
Xout_reg_0 clk n_6 out_0 VDD VSS / DFFQX1
Xout_reg_1 clk n_5 out_1 VDD VSS / DFFQX1
Xg7 res n_1 n_7 VDD VSS / NOR2X1
Xg8 res n_2 n_6 VDD VSS / NOR2X1
Xg9 res n_0 n_5 VDD VSS / NOR2X1
Xg10 res n_3 n_4 VDD VSS / NOR2X1
Xg11 in_2 n_3 VDD VSS / CLKINVX1
Xg12 in_0 n_2 VDD VSS / CLKINVX1
Xg13 in_3 n_1 VDD VSS / CLKINVX1
Xg14 in_1 n_0 VDD VSS / CLKINVX1
.ENDS delay1_4_364

*******************************************************************************
* MODULE: delay1_4_365
*******************************************************************************
.SUBCKT delay1_4_365 clk res in_0 in_1 in_2 in_3 out_0 out_1 out_2 out_3 VDD VSS
Xout_reg_3 clk n_7 out_3 VDD VSS / DFFQX1
Xout_reg_2 clk n_4 out_2 VDD VSS / DFFQX1
Xout_reg_0 clk n_6 out_0 VDD VSS / DFFQX1
Xout_reg_1 clk n_5 out_1 VDD VSS / DFFQX1
Xg7 res n_1 n_7 VDD VSS / NOR2X1
Xg8 res n_2 n_6 VDD VSS / NOR2X1
Xg9 res n_0 n_5 VDD VSS / NOR2X1
Xg10 res n_3 n_4 VDD VSS / NOR2X1
Xg11 in_2 n_3 VDD VSS / CLKINVX1
Xg12 in_0 n_2 VDD VSS / CLKINVX1
Xg13 in_3 n_1 VDD VSS / CLKINVX1
Xg14 in_1 n_0 VDD VSS / CLKINVX1
.ENDS delay1_4_365

*******************************************************************************
* MODULE: delay1_4_366
*******************************************************************************
.SUBCKT delay1_4_366 clk res in_0 in_1 in_2 in_3 out_0 out_1 out_2 out_3 VDD VSS
Xout_reg_3 clk n_7 out_3 VDD VSS / DFFQX1
Xout_reg_2 clk n_4 out_2 VDD VSS / DFFQX1
Xout_reg_0 clk n_6 out_0 VDD VSS / DFFQX1
Xout_reg_1 clk n_5 out_1 VDD VSS / DFFQX1
Xg7 res n_1 n_7 VDD VSS / NOR2X1
Xg8 res n_2 n_6 VDD VSS / NOR2X1
Xg9 res n_0 n_5 VDD VSS / NOR2X1
Xg10 res n_3 n_4 VDD VSS / NOR2X1
Xg11 in_2 n_3 VDD VSS / CLKINVX1
Xg12 in_0 n_2 VDD VSS / CLKINVX1
Xg13 in_3 n_1 VDD VSS / CLKINVX1
Xg14 in_1 n_0 VDD VSS / CLKINVX1
.ENDS delay1_4_366

*******************************************************************************
* MODULE: delay1_4_367
*******************************************************************************
.SUBCKT delay1_4_367 clk res in_0 in_1 in_2 in_3 out_0 out_1 out_2 out_3 VDD VSS
Xout_reg_3 clk n_7 out_3 VDD VSS / DFFQX1
Xout_reg_2 clk n_4 out_2 VDD VSS / DFFQX1
Xout_reg_0 clk n_6 out_0 VDD VSS / DFFQX1
Xout_reg_1 clk n_5 out_1 VDD VSS / DFFQX1
Xg7 n_1 res n_7 VDD VSS / NOR2X1
Xg8 n_2 res n_6 VDD VSS / NOR2X1
Xg9 n_0 res n_5 VDD VSS / NOR2X1
Xg10 n_3 res n_4 VDD VSS / NOR2X1
Xg11 in_2 n_3 VDD VSS / CLKINVX1
Xg12 in_0 n_2 VDD VSS / CLKINVX1
Xg13 in_3 n_1 VDD VSS / CLKINVX1
Xg14 in_1 n_0 VDD VSS / CLKINVX1
.ENDS delay1_4_367

*******************************************************************************
* MODULE: delay1_4_368
*******************************************************************************
.SUBCKT delay1_4_368 clk res in_0 in_1 in_2 in_3 out_0 out_1 out_2 out_3 VDD VSS
Xout_reg_3 clk n_7 out_3 VDD VSS / DFFQX1
Xout_reg_2 clk n_4 out_2 VDD VSS / DFFQX1
Xout_reg_0 clk n_6 out_0 VDD VSS / DFFQX1
Xout_reg_1 clk n_5 out_1 VDD VSS / DFFQX1
Xg7 res n_1 n_7 VDD VSS / NOR2X1
Xg8 res n_2 n_6 VDD VSS / NOR2X1
Xg9 res n_0 n_5 VDD VSS / NOR2X1
Xg10 res n_3 n_4 VDD VSS / NOR2X1
Xg11 in_2 n_3 VDD VSS / CLKINVX1
Xg12 in_0 n_2 VDD VSS / CLKINVX1
Xg13 in_3 n_1 VDD VSS / CLKINVX1
Xg14 in_1 n_0 VDD VSS / CLKINVX1
.ENDS delay1_4_368

*******************************************************************************
* MODULE: delay1_4_369
*******************************************************************************
.SUBCKT delay1_4_369 clk res in_0 in_1 in_2 in_3 out_0 out_1 out_2 out_3 VDD VSS
Xout_reg_3 clk n_7 out_3 VDD VSS / DFFQX1
Xout_reg_2 clk n_4 out_2 VDD VSS / DFFQX1
Xout_reg_0 clk n_6 out_0 VDD VSS / DFFQX1
Xout_reg_1 clk n_5 out_1 VDD VSS / DFFQX1
Xg7 res n_1 n_7 VDD VSS / NOR2X1
Xg8 res n_2 n_6 VDD VSS / NOR2X1
Xg9 res n_0 n_5 VDD VSS / NOR2X1
Xg10 res n_3 n_4 VDD VSS / NOR2X1
Xg11 in_2 n_3 VDD VSS / CLKINVX1
Xg12 in_0 n_2 VDD VSS / CLKINVX1
Xg13 in_3 n_1 VDD VSS / CLKINVX1
Xg14 in_1 n_0 VDD VSS / CLKINVX1
.ENDS delay1_4_369

*******************************************************************************
* MODULE: delay1_4_370
*******************************************************************************
.SUBCKT delay1_4_370 clk res in_0 in_1 in_2 in_3 out_0 out_1 out_2 out_3 VDD VSS
Xout_reg_3 clk n_7 out_3 VDD VSS / DFFQX1
Xout_reg_2 clk n_4 out_2 VDD VSS / DFFQX1
Xout_reg_0 clk n_6 out_0 VDD VSS / DFFQX1
Xout_reg_1 clk n_5 out_1 VDD VSS / DFFQX1
Xg7 res n_1 n_7 VDD VSS / NOR2X1
Xg8 res n_2 n_6 VDD VSS / NOR2X1
Xg9 res n_0 n_5 VDD VSS / NOR2X1
Xg10 res n_3 n_4 VDD VSS / NOR2X1
Xg11 in_2 n_3 VDD VSS / CLKINVX1
Xg12 in_0 n_2 VDD VSS / CLKINVX1
Xg13 in_3 n_1 VDD VSS / CLKINVX1
Xg14 in_1 n_0 VDD VSS / CLKINVX1
.ENDS delay1_4_370

*******************************************************************************
* MODULE: delay1_4_371
*******************************************************************************
.SUBCKT delay1_4_371 clk res in_0 in_1 in_2 in_3 out_0 out_1 out_2 out_3 VDD VSS
Xout_reg_3 clk n_7 out_3 VDD VSS / DFFQX1
Xout_reg_2 clk n_4 out_2 VDD VSS / DFFQX1
Xout_reg_0 clk n_6 out_0 VDD VSS / DFFQX1
Xout_reg_1 clk n_5 out_1 VDD VSS / DFFQX1
Xg7 n_1 res n_7 VDD VSS / NOR2X1
Xg8 n_2 res n_6 VDD VSS / NOR2X1
Xg9 n_0 res n_5 VDD VSS / NOR2X1
Xg10 n_3 res n_4 VDD VSS / NOR2X1
Xg11 in_2 n_3 VDD VSS / CLKINVX1
Xg12 in_0 n_2 VDD VSS / CLKINVX1
Xg13 in_3 n_1 VDD VSS / CLKINVX1
Xg14 in_1 n_0 VDD VSS / CLKINVX1
.ENDS delay1_4_371

*******************************************************************************
* MODULE: delay1_4_372
*******************************************************************************
.SUBCKT delay1_4_372 clk res in_0 in_1 in_2 in_3 out_0 out_1 out_2 out_3 VDD VSS
Xout_reg_3 clk n_7 out_3 VDD VSS / DFFQX1
Xout_reg_2 clk n_4 out_2 VDD VSS / DFFQX1
Xout_reg_0 clk n_6 out_0 VDD VSS / DFFQX1
Xout_reg_1 clk n_5 out_1 VDD VSS / DFFQX1
Xg7 res n_1 n_7 VDD VSS / NOR2X1
Xg8 res n_2 n_6 VDD VSS / NOR2X1
Xg9 res n_0 n_5 VDD VSS / NOR2X1
Xg10 res n_3 n_4 VDD VSS / NOR2X1
Xg11 in_2 n_3 VDD VSS / CLKINVX1
Xg12 in_0 n_2 VDD VSS / CLKINVX1
Xg13 in_3 n_1 VDD VSS / CLKINVX1
Xg14 in_1 n_0 VDD VSS / CLKINVX1
.ENDS delay1_4_372

*******************************************************************************
* MODULE: delay1_4_373
*******************************************************************************
.SUBCKT delay1_4_373 clk res in_0 in_1 in_2 in_3 out_0 out_1 out_2 out_3 VDD VSS
Xout_reg_3 clk n_7 out_3 VDD VSS / DFFQX1
Xout_reg_2 clk n_4 out_2 VDD VSS / DFFQX1
Xout_reg_0 clk n_6 out_0 VDD VSS / DFFQX1
Xout_reg_1 clk n_5 out_1 VDD VSS / DFFQX1
Xg7 res n_1 n_7 VDD VSS / NOR2X1
Xg8 res n_2 n_6 VDD VSS / NOR2X1
Xg9 res n_0 n_5 VDD VSS / NOR2X1
Xg10 res n_3 n_4 VDD VSS / NOR2X1
Xg11 in_2 n_3 VDD VSS / CLKINVX1
Xg12 in_0 n_2 VDD VSS / CLKINVX1
Xg13 in_3 n_1 VDD VSS / CLKINVX1
Xg14 in_1 n_0 VDD VSS / CLKINVX1
.ENDS delay1_4_373

*******************************************************************************
* MODULE: delay1_4_374
*******************************************************************************
.SUBCKT delay1_4_374 clk res in_0 in_1 in_2 in_3 out_0 out_1 out_2 out_3 VDD VSS
Xout_reg_3 clk n_7 out_3 VDD VSS / DFFQX1
Xout_reg_2 clk n_4 out_2 VDD VSS / DFFQX1
Xout_reg_0 clk n_6 out_0 VDD VSS / DFFQX1
Xout_reg_1 clk n_5 out_1 VDD VSS / DFFQX1
Xg7 res n_1 n_7 VDD VSS / NOR2X1
Xg8 res n_2 n_6 VDD VSS / NOR2X1
Xg9 res n_0 n_5 VDD VSS / NOR2X1
Xg10 res n_3 n_4 VDD VSS / NOR2X1
Xg11 in_2 n_3 VDD VSS / CLKINVX1
Xg12 in_0 n_2 VDD VSS / CLKINVX1
Xg13 in_3 n_1 VDD VSS / CLKINVX1
Xg14 in_1 n_0 VDD VSS / CLKINVX1
.ENDS delay1_4_374

*******************************************************************************
* MODULE: delay1_4_375
*******************************************************************************
.SUBCKT delay1_4_375 clk res in_0 in_1 in_2 in_3 out_0 out_1 out_2 out_3 VDD VSS
Xout_reg_3 clk n_7 out_3 VDD VSS / DFFQX1
Xout_reg_2 clk n_4 out_2 VDD VSS / DFFQX1
Xout_reg_0 clk n_6 out_0 VDD VSS / DFFQX1
Xout_reg_1 clk n_5 out_1 VDD VSS / DFFQX1
Xg7 res n_1 n_7 VDD VSS / NOR2X1
Xg8 res n_2 n_6 VDD VSS / NOR2X1
Xg9 res n_0 n_5 VDD VSS / NOR2X1
Xg10 res n_3 n_4 VDD VSS / NOR2X1
Xg11 in_2 n_3 VDD VSS / CLKINVX1
Xg12 in_0 n_2 VDD VSS / CLKINVX1
Xg13 in_3 n_1 VDD VSS / CLKINVX1
Xg14 in_1 n_0 VDD VSS / CLKINVX1
.ENDS delay1_4_375

*******************************************************************************
* MODULE: gen_din_sel4
*******************************************************************************
.SUBCKT gen_din_sel4 clk res din select_initial VDD VSS
Xsel_i_reg_reg clk res select_initial VDD VSS / DFFQX1
.ENDS gen_din_sel4

*******************************************************************************
* MODULE: nn_core4 (TOP)
*******************************************************************************
.SUBCKT nn_core4 clk res update_coeff
+ input_k1_0 input_k1_1 input_k1_2 input_k1_3
+ input_k2_0 input_k2_1 input_k2_2 input_k2_3
+ finish_updating
+ a3_1_0 a3_1_1 a3_1_2 a3_1_3
+ VDD VSS

*--- finish_updating tied VSS (assign finish_updating=1b0) ---*

*--- Reset buffer chain ---*
Xg3 res n_0 VDD VSS / CLKINVX1
Xg1 n_0 n_4 VDD VSS / CLKINVX1
Xg7 n_0 n_8 VDD VSS / CLKINVX1
Xg8 n_0 n_5 VDD VSS / CLKINVX1
Xg11 n_0 n_11 VDD VSS / CLKINVX1
Xg10 n_0 n_9 VDD VSS / CLKINVX1

*--- gen_din_sel4: generates select_initial ---*
XGDS clk n_5 UNCONNECTED77 select_initial VDD VSS / gen_din_sel4

*--- a2_1 delay chain (2 stages) ---*
XDA2_1 clk n_11 a2_1_0 a2_1_1 a2_1_2 a2_1_3 tmp_a2_1_0 tmp_a2_1_1 tmp_a2_1_2 tmp_a2_1_3 VDD VSS / delay1_4_375
XDA2_3 clk res tmp_a2_1_0 tmp_a2_1_1 tmp_a2_1_2 tmp_a2_1_3 tmp2_a2_1_0 tmp2_a2_1_1 tmp2_a2_1_2 tmp2_a2_1_3 VDD VSS / delay1_4_373

*--- a2_2 delay chain (2 stages) ---*
XDA2_2 clk n_5 a2_2_0 a2_2_1 a2_2_2 a2_2_3 tmp_a2_2_0 tmp_a2_2_1 tmp_a2_2_2 tmp_a2_2_3 VDD VSS / delay1_4_374
XDA2_4 clk n_8 tmp_a2_2_0 tmp_a2_2_1 tmp_a2_2_2 tmp_a2_2_3 tmp2_a2_2_0 tmp2_a2_2_1 tmp2_a2_2_2 tmp2_a2_2_3 VDD VSS / delay1_4_372

*--- k1 delay chain (4 stages) ---*
XDK1_1 clk n_11 k1_0 k1_1 k1_2 k1_3 tmp_k1_0 tmp_k1_1 tmp_k1_2 tmp_k1_3 VDD VSS / delay1_4_371
XDK1_2 clk n_9 tmp_k1_0 tmp_k1_1 tmp_k1_2 tmp_k1_3 tmp2_k1_0 tmp2_k1_1 tmp2_k1_2 tmp2_k1_3 VDD VSS / delay1_4_370
XDK1_3 clk res tmp2_k1_0 tmp2_k1_1 tmp2_k1_2 tmp2_k1_3 tmp3_k1_0 tmp3_k1_1 tmp3_k1_2 tmp3_k1_3 VDD VSS / delay1_4_369
XDK1_4 clk res tmp3_k1_0 tmp3_k1_1 tmp3_k1_2 tmp3_k1_3 tmp4_k1_0 tmp4_k1_1 tmp4_k1_2 tmp4_k1_3 VDD VSS / delay1_4_368

*--- k2 delay chain (4 stages) ---*
XDK2_1 clk n_9 k2_0 k2_1 k2_2 k2_3 tmp_k2_0 tmp_k2_1 tmp_k2_2 tmp_k2_3 VDD VSS / delay1_4_367
XDK2_2 clk n_8 tmp_k2_0 tmp_k2_1 tmp_k2_2 tmp_k2_3 tmp2_k2_0 tmp2_k2_1 tmp2_k2_2 tmp2_k2_3 VDD VSS / delay1_4_366
XDK2_3 clk res tmp2_k2_0 tmp2_k2_1 tmp2_k2_2 tmp2_k2_3 tmp3_k2_0 tmp3_k2_1 tmp3_k2_2 tmp3_k2_3 VDD VSS / delay1_4_365
XDK2_4 clk n_5 tmp3_k2_0 tmp3_k2_1 tmp3_k2_2 tmp3_k2_3 tmp4_k2_0 tmp4_k2_1 tmp4_k2_2 tmp4_k2_3 VDD VSS / delay1_4_364

*--- t1 delay chain (4 stages, only bit[2] used) ---*
* DT1_1: in={UNC_Z60,UNC_Z59,UNC_Z58,t1[2]} out={UNC63,tmp_t1[2],UNC62,UNC61}
XDT1_1 clk n_5 t1_2 UNCONNECTED_HIER_Z58 UNCONNECTED_HIER_Z59 UNCONNECTED_HIER_Z60 UNCONNECTED61 UNCONNECTED62 tmp_t1_2 UNCONNECTED63 VDD VSS / delay1_4_36
* DT1_2: in={UNC_Z63,UNC_Z62,UNC_Z61,tmp_t1[2]} out={UNC66,tmp2_t1[2],UNC65,UNC64}
XDT1_2 clk n_5 tmp_t1_2 UNCONNECTED_HIER_Z61 UNCONNECTED_HIER_Z62 UNCONNECTED_HIER_Z63 UNCONNECTED64 UNCONNECTED65 tmp2_t1_2 UNCONNECTED66 VDD VSS / delay1_4_37
* DT1_3: in={UNC_Z66,UNC_Z65,UNC_Z64,tmp2_t1[2]} out={UNC69,tmp3_t1[2],UNC68,UNC67}
XDT1_3 clk n_5 tmp2_t1_2 UNCONNECTED_HIER_Z64 UNCONNECTED_HIER_Z65 UNCONNECTED_HIER_Z66 UNCONNECTED67 UNCONNECTED68 tmp3_t1_2 UNCONNECTED69 VDD VSS / delay1_4_38
* DT1_4: in={UNC_Z69,UNC_Z68,UNC_Z67,tmp3_t1[2]} out={UNC72,tmp4_t1[2],UNC71,UNC70}
XDT1_4 clk n_5 tmp3_t1_2 UNCONNECTED_HIER_Z67 UNCONNECTED_HIER_Z68 UNCONNECTED_HIER_Z69 UNCONNECTED70 UNCONNECTED71 tmp4_t1_2 UNCONNECTED72 VDD VSS / delay1_4_39

*--- forward4 ---*
* cap_dw connections: forward4 expects {UNC,UNC,cap_dw_X[3],cap_dw_X[0]}
XFWD clk n_4 UNCONNECTED_HIER_Z70 select_initial update_coeff
+ input_k1_0 input_k1_1 input_k1_2 input_k1_3
+ input_k2_0 input_k2_1 input_k2_2 input_k2_3
+ cap_dw2_11_0 UNCONNECTED_HIER_Z71 UNCONNECTED_HIER_Z72 cap_dw2_11_3
+ cap_dw2_21_0 UNCONNECTED_HIER_Z73 UNCONNECTED_HIER_Z74 cap_dw2_21_3
+ cap_dw2_12_0 UNCONNECTED_HIER_Z75 UNCONNECTED_HIER_Z76 cap_dw2_12_3
+ cap_dw2_22_0 UNCONNECTED_HIER_Z77 UNCONNECTED_HIER_Z78 cap_dw2_22_3
+ cap_dw3_11_0 UNCONNECTED_HIER_Z79 UNCONNECTED_HIER_Z80 cap_dw3_11_3
+ cap_dw3_21_0 UNCONNECTED_HIER_Z81 UNCONNECTED_HIER_Z82 cap_dw3_21_3
+ cap_db2_1_0 UNCONNECTED_HIER_Z83 UNCONNECTED_HIER_Z84 UNCONNECTED_HIER_Z85
+ cap_db2_2_0 UNCONNECTED_HIER_Z86 UNCONNECTED_HIER_Z87 UNCONNECTED_HIER_Z88
+ cap_db3_1_0 UNCONNECTED_HIER_Z89 UNCONNECTED_HIER_Z90 cap_db3_1_3
+ w3_11_0 w3_11_1 w3_11_2 w3_11_3
+ w3_21_0 w3_21_1 w3_21_2 w3_21_3
+ a2_1_0 a2_1_1 a2_1_2 a2_1_3
+ a2_2_0 a2_2_1 a2_2_2 a2_2_3
+ a3_1_0 a3_1_1 a3_1_2 a3_1_3
+ k1_0 k1_1 k1_2 k1_3
+ k2_0 k2_1 k2_2 k2_3
+ UNCONNECTED73 t1_2 UNCONNECTED74 UNCONNECTED75
+ UNCONNECTED76 VDD VSS / forward4

*--- backward4 ---*
* t1 input: only t1[2]=tmp4_t1[2] used, rest UNC
* cap_dw outputs: bits 1,2 undriven → float
XBWD clk n_4
+ a3_1_0 a3_1_1 a3_1_2 a3_1_3
+ tmp2_a2_1_0 tmp2_a2_1_1 tmp2_a2_1_2 tmp2_a2_1_3
+ tmp2_a2_2_0 tmp2_a2_2_1 tmp2_a2_2_2 tmp2_a2_2_3
+ tmp4_k1_0 tmp4_k1_1 tmp4_k1_2 tmp4_k1_3
+ tmp4_k2_0 tmp4_k2_1 tmp4_k2_2 tmp4_k2_3
+ UNCONNECTED_HIER_Z55 UNCONNECTED_HIER_Z56 UNCONNECTED_HIER_Z57 tmp4_t1_2
+ w3_11_0 w3_11_1 w3_11_2 w3_11_3
+ w3_21_0 w3_21_1 w3_21_2 w3_21_3
+ cap_dw3_11_0 UNCONNECTED41 UNCONNECTED42 cap_dw3_11_3
+ cap_dw3_21_0 UNCONNECTED43 UNCONNECTED44 cap_dw3_21_3
+ cap_dw2_11_0 UNCONNECTED45 UNCONNECTED46 cap_dw2_11_3
+ cap_dw2_21_0 UNCONNECTED47 UNCONNECTED48 cap_dw2_21_3
+ cap_dw2_12_0 UNCONNECTED49 UNCONNECTED50 cap_dw2_12_3
+ cap_dw2_22_0 UNCONNECTED51 UNCONNECTED52 cap_dw2_22_3
+ cap_db3_1_0 UNCONNECTED53 UNCONNECTED54 cap_db3_1_3
+ cap_db2_1_0 UNCONNECTED55 UNCONNECTED56 UNCONNECTED57
+ cap_db2_2_0 UNCONNECTED58 UNCONNECTED59 UNCONNECTED60
+ VDD VSS / backward4

.ENDS nn_core4

* End nn_core4.cdl
