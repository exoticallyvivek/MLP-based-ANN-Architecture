*******************************************************************************
* forward4.cdl — All sub-modules + forward4 top
* Syntax: mem4_slim.cdl working reference (/ CELLNAME style)
* Ref libs needed on import: gpdk090, your stdcel lib (has mem4)
*******************************************************************************

*=== gpdk090 STD CELL STUBS (real layouts in your stdcel lib) ===*
.SUBCKT INVX1 A Y VDD VSS
*.PININFO A:I Y:O VDD:I VSS:I
.ENDS INVX1

.SUBCKT DFFQX1 CK D Q VDD VSS
*.PININFO CK:I D:I Q:O VDD:I VSS:I
.ENDS DFFQX1

.SUBCKT NOR2X1 A B Y VDD VSS
*.PININFO A:I B:I Y:O VDD:I VSS:I
.ENDS NOR2X1

.SUBCKT NAND2X1 A B Y VDD VSS
*.PININFO A:I B:I Y:O VDD:I VSS:I
.ENDS NAND2X1

.SUBCKT XNOR2X1 A B Y VDD VSS
*.PININFO A:I B:I Y:O VDD:I VSS:I
.ENDS XNOR2X1

*=== DERIVED WRAPPERS (built from stubs above) ===*
.SUBCKT AND2X1 A B Y VDD VSS
XNAND1 A B n_ab VDD VSS / NAND2X1
XINV1 n_ab Y VDD VSS / INVX1
.ENDS AND2X1

.SUBCKT OR2X1 A B Y VDD VSS
XNOR1 A B n_ab VDD VSS / NOR2X1
XINV1 n_ab Y VDD VSS / INVX1
.ENDS OR2X1

.SUBCKT XOR2X1 A B Y VDD VSS
XXNOR1 A B n_ab VDD VSS / XNOR2X1
XINV1 n_ab Y VDD VSS / INVX1
.ENDS XOR2X1

.SUBCKT MX2X1 A B S0 Y VDD VSS
XINV_S0 S0 S0b VDD VSS / INVX1
XNA A S0b na VDD VSS / NAND2X1
XNB B S0 nb VDD VSS / NAND2X1
XOUT na nb Y VDD VSS / NAND2X1
.ENDS MX2X1

.SUBCKT CLKINVX1 A Y VDD VSS
XINV1 A Y VDD VSS / INVX1
.ENDS CLKINVX1

.SUBCKT CLKXOR2X1 A B Y VDD VSS
XXOR1 A B Y VDD VSS / XOR2X1
.ENDS CLKXOR2X1

* SE=0: Q=D (normal); SE=1: Q=SI (scan)
.SUBCKT SDFFQX1 CK D SI SE Q VDD VSS
XMUX1 D SI SE net_mux VDD VSS / MX2X1
XDFF1 CK net_mux Q VDD VSS / DFFQX1
.ENDS SDFFQX1

*=== mem4 STUB (real schematic in stdcel lib) ===*
.SUBCKT mem4 CLK DIN ADDR3 ADDR2 ADDR1 ADDR0 DOUT3 DOUT2 DOUT1 DOUT0 VDD VSS
*.PININFO CLK:I DIN:I ADDR3:I ADDR2:I ADDR1:I ADDR0:I
*.PININFO DOUT3:O DOUT2:O DOUT1:O DOUT0:O VDD:I VSS:I
.ENDS mem4

*******************************************************************************
* MODULE: delay1_4
*******************************************************************************
.SUBCKT delay1_4 clk res in_0 in_1 in_2 in_3 out_0 out_1 out_2 out_3 VDD VSS
Xout_reg_3 clk n_7 out_3 VDD VSS / DFFQX1
Xout_reg_2 clk n_4 out_2 VDD VSS / DFFQX1
Xout_reg_0 clk n_6 out_0 VDD VSS / DFFQX1
Xout_reg_1 clk n_5 out_1 VDD VSS / DFFQX1
Xg7__1666 res n_1 n_7 VDD VSS / NOR2X1
Xg8__7410 res n_2 n_6 VDD VSS / NOR2X1
Xg9__6417 res n_0 n_5 VDD VSS / NOR2X1
Xg10__5477 res n_3 n_4 VDD VSS / NOR2X1
Xg11 in_2 n_3 VDD VSS / CLKINVX1
Xg12 in_0 n_2 VDD VSS / CLKINVX1
Xg13 in_3 n_1 VDD VSS / CLKINVX1
Xg14 in_1 n_0 VDD VSS / CLKINVX1
.ENDS delay1_4

*******************************************************************************
* MODULE: delay1_4_1
*******************************************************************************
.SUBCKT delay1_4_1 clk res in_0 in_1 in_2 in_3 out_0 out_1 out_2 out_3 VDD VSS
Xout_reg_0 clk n_2 out_2 VDD VSS / DFFQX1
Xg4__6161 res n_1 n_2 VDD VSS / NOR2X1
Xg5 in_0 n_1 VDD VSS / CLKINVX1
.ENDS delay1_4_1

*******************************************************************************
* MODULE: delay1_4_2
*******************************************************************************
.SUBCKT delay1_4_2 clk res in_0 in_1 in_2 in_3 out_0 out_1 out_2 out_3 VDD VSS
Xout_reg_1 clk n_3 out_1 VDD VSS / DFFQX1
Xout_reg_0 clk n_4 out_0 VDD VSS / DFFQX1
Xg5__6783 res n_1 n_4 VDD VSS / NOR2X1
Xg6__3680 res n_2 n_3 VDD VSS / NOR2X1
Xg7 in_1 n_2 VDD VSS / CLKINVX1
Xg8 in_0 n_1 VDD VSS / CLKINVX1
.ENDS delay1_4_2

*******************************************************************************
* MODULE: delay1_4_2_396
*******************************************************************************
.SUBCKT delay1_4_2_396 clk res in_0 in_1 in_2 in_3 out_0 out_1 out_2 out_3 VDD VSS
Xout_reg_1 clk n_3 out_1 VDD VSS / DFFQX1
Xout_reg_0 clk n_4 out_0 VDD VSS / DFFQX1
Xg5__1617 res n_1 n_4 VDD VSS / NOR2X1
Xg6__2802 res n_2 n_3 VDD VSS / NOR2X1
Xg7 in_1 n_2 VDD VSS / CLKINVX1
Xg8 in_0 n_1 VDD VSS / CLKINVX1
.ENDS delay1_4_2_396

*******************************************************************************
* MODULE: delay1_4_376
*******************************************************************************
.SUBCKT delay1_4_376 clk res in_0 in_1 in_2 in_3 out_0 out_1 out_2 out_3 VDD VSS
Xout_reg_2 clk n_3 out_2 VDD VSS / DFFQX1
Xout_reg_0 clk n_5 out_0 VDD VSS / DFFQX1
Xout_reg_1 clk n_4 out_1 VDD VSS / DFFQX1
Xg6__7098 res n_0 n_5 VDD VSS / NOR2X1
Xg7__6131 res n_1 n_4 VDD VSS / NOR2X1
Xg8__1881 res n_2 n_3 VDD VSS / NOR2X1
Xg9 in_2 n_2 VDD VSS / CLKINVX1
Xg10 in_1 n_1 VDD VSS / CLKINVX1
Xg11 in_0 n_0 VDD VSS / CLKINVX1
.ENDS delay1_4_376

*******************************************************************************
* MODULE: delay1_4_377
*******************************************************************************
.SUBCKT delay1_4_377 clk res in_0 in_1 in_2 in_3 out_0 out_1 out_2 out_3 VDD VSS
Xout_reg_2 clk n_3 out_2 VDD VSS / DFFQX1
Xout_reg_0 clk n_5 out_0 VDD VSS / DFFQX1
Xout_reg_1 clk n_4 out_1 VDD VSS / DFFQX1
Xg6__1705 res n_0 n_5 VDD VSS / NOR2X1
Xg7__5122 res n_1 n_4 VDD VSS / NOR2X1
Xg8__8246 res n_2 n_3 VDD VSS / NOR2X1
Xg9 in_2 n_2 VDD VSS / CLKINVX1
Xg10 in_1 n_1 VDD VSS / CLKINVX1
Xg11 in_0 n_0 VDD VSS / CLKINVX1
.ENDS delay1_4_377

*******************************************************************************
* MODULE: delay1_4_378
*******************************************************************************
.SUBCKT delay1_4_378 clk res in_0 in_1 in_2 in_3 out_0 out_1 out_2 out_3 VDD VSS
Xout_reg_3 clk n_7 out_3 VDD VSS / DFFQX1
Xout_reg_2 clk n_4 out_2 VDD VSS / DFFQX1
Xout_reg_0 clk n_6 out_0 VDD VSS / DFFQX1
Xout_reg_1 clk n_5 out_1 VDD VSS / DFFQX1
Xg7__1881 res n_1 n_7 VDD VSS / NOR2X1
Xg8__5115 res n_2 n_6 VDD VSS / NOR2X1
Xg9__7482 res n_0 n_5 VDD VSS / NOR2X1
Xg10__4733 res n_3 n_4 VDD VSS / NOR2X1
Xg11 in_2 n_3 VDD VSS / CLKINVX1
Xg12 in_0 n_2 VDD VSS / CLKINVX1
Xg13 in_3 n_1 VDD VSS / CLKINVX1
Xg14 in_1 n_0 VDD VSS / CLKINVX1
.ENDS delay1_4_378

*******************************************************************************
* MODULE: delay1_4_379
*******************************************************************************
.SUBCKT delay1_4_379 clk res in_0 in_1 in_2 in_3 out_0 out_1 out_2 out_3 VDD VSS
Xout_reg_3 clk n_7 out_3 VDD VSS / DFFQX1
Xout_reg_2 clk n_4 out_2 VDD VSS / DFFQX1
Xout_reg_0 clk n_6 out_0 VDD VSS / DFFQX1
Xout_reg_1 clk n_5 out_1 VDD VSS / DFFQX1
Xg7__5122 res n_1 n_7 VDD VSS / NOR2X1
Xg8__8246 res n_2 n_6 VDD VSS / NOR2X1
Xg9__7098 res n_0 n_5 VDD VSS / NOR2X1
Xg10__6131 res n_3 n_4 VDD VSS / NOR2X1
Xg11 in_2 n_3 VDD VSS / CLKINVX1
Xg12 in_0 n_2 VDD VSS / CLKINVX1
Xg13 in_3 n_1 VDD VSS / CLKINVX1
Xg14 in_1 n_0 VDD VSS / CLKINVX1
.ENDS delay1_4_379

*******************************************************************************
* MODULE: delay1_4_380
*******************************************************************************
.SUBCKT delay1_4_380 clk res in_0 in_1 in_2 in_3 out_0 out_1 out_2 out_3 VDD VSS
Xout_reg_3 clk n_7 out_3 VDD VSS / DFFQX1
Xout_reg_2 clk n_4 out_2 VDD VSS / DFFQX1
Xout_reg_0 clk n_6 out_0 VDD VSS / DFFQX1
Xout_reg_1 clk n_5 out_1 VDD VSS / DFFQX1
Xg7__3680 res n_1 n_7 VDD VSS / NOR2X1
Xg8__1617 res n_2 n_6 VDD VSS / NOR2X1
Xg9__2802 res n_0 n_5 VDD VSS / NOR2X1
Xg10__1705 res n_3 n_4 VDD VSS / NOR2X1
Xg11 in_2 n_3 VDD VSS / CLKINVX1
Xg12 in_0 n_2 VDD VSS / CLKINVX1
Xg13 in_3 n_1 VDD VSS / CLKINVX1
Xg14 in_1 n_0 VDD VSS / CLKINVX1
.ENDS delay1_4_380

*******************************************************************************
* MODULE: delay1_4_381
*******************************************************************************
.SUBCKT delay1_4_381 clk res in_0 in_1 in_2 in_3 out_0 out_1 out_2 out_3 VDD VSS
Xout_reg_3 clk n_7 out_3 VDD VSS / DFFQX1
Xout_reg_2 clk n_4 out_2 VDD VSS / DFFQX1
Xout_reg_0 clk n_6 out_0 VDD VSS / DFFQX1
Xout_reg_1 clk n_5 out_1 VDD VSS / DFFQX1
Xg7__4319 res n_1 n_7 VDD VSS / NOR2X1
Xg8__8428 res n_2 n_6 VDD VSS / NOR2X1
Xg9__5526 res n_0 n_5 VDD VSS / NOR2X1
Xg10__6783 res n_3 n_4 VDD VSS / NOR2X1
Xg11 in_2 n_3 VDD VSS / CLKINVX1
Xg12 in_0 n_2 VDD VSS / CLKINVX1
Xg13 in_3 n_1 VDD VSS / CLKINVX1
Xg14 in_1 n_0 VDD VSS / CLKINVX1
.ENDS delay1_4_381

*******************************************************************************
* MODULE: delay1_4_382
*******************************************************************************
.SUBCKT delay1_4_382 clk res in_0 in_1 in_2 in_3 out_0 out_1 out_2 out_3 VDD VSS
Xout_reg_3 clk n_7 out_3 VDD VSS / DFFQX1
Xout_reg_2 clk n_4 out_2 VDD VSS / DFFQX1
Xout_reg_0 clk n_6 out_0 VDD VSS / DFFQX1
Xout_reg_1 clk n_5 out_1 VDD VSS / DFFQX1
Xg7__5477 res n_1 n_7 VDD VSS / NOR2X1
Xg8__2398 res n_2 n_6 VDD VSS / NOR2X1
Xg9__5107 res n_0 n_5 VDD VSS / NOR2X1
Xg10__6260 res n_3 n_4 VDD VSS / NOR2X1
Xg11 in_2 n_3 VDD VSS / CLKINVX1
Xg12 in_0 n_2 VDD VSS / CLKINVX1
Xg13 in_3 n_1 VDD VSS / CLKINVX1
Xg14 in_1 n_0 VDD VSS / CLKINVX1
.ENDS delay1_4_382

*******************************************************************************
* MODULE: delay1_4_383
*******************************************************************************
.SUBCKT delay1_4_383 clk res in_0 in_1 in_2 in_3 out_0 out_1 out_2 out_3 VDD VSS
Xout_reg_3 clk n_7 out_3 VDD VSS / DFFQX1
Xout_reg_2 clk n_4 out_2 VDD VSS / DFFQX1
Xout_reg_0 clk n_6 out_0 VDD VSS / DFFQX1
Xout_reg_1 clk n_5 out_1 VDD VSS / DFFQX1
Xg7__2346 res n_1 n_7 VDD VSS / NOR2X1
Xg8__1666 res n_2 n_6 VDD VSS / NOR2X1
Xg9__7410 res n_0 n_5 VDD VSS / NOR2X1
Xg10__6417 res n_3 n_4 VDD VSS / NOR2X1
Xg11 in_2 n_3 VDD VSS / CLKINVX1
Xg12 in_0 n_2 VDD VSS / CLKINVX1
Xg13 in_3 n_1 VDD VSS / CLKINVX1
Xg14 in_1 n_0 VDD VSS / CLKINVX1
.ENDS delay1_4_383

*******************************************************************************
* MODULE: delay1_4_384
*******************************************************************************
.SUBCKT delay1_4_384 clk res in_0 in_1 in_2 in_3 out_0 out_1 out_2 out_3 VDD VSS
Xout_reg_3 clk n_7 out_3 VDD VSS / DFFQX1
Xout_reg_2 clk n_4 out_2 VDD VSS / DFFQX1
Xout_reg_0 clk n_6 out_0 VDD VSS / DFFQX1
Xout_reg_1 clk n_5 out_1 VDD VSS / DFFQX1
Xg7__9315 res n_1 n_7 VDD VSS / NOR2X1
Xg8__9945 res n_2 n_6 VDD VSS / NOR2X1
Xg9__2883 res n_0 n_5 VDD VSS / NOR2X1
Xg10__2346 res n_3 n_4 VDD VSS / NOR2X1
Xg11 in_2 n_3 VDD VSS / CLKINVX1
Xg12 in_0 n_2 VDD VSS / CLKINVX1
Xg13 in_3 n_1 VDD VSS / CLKINVX1
Xg14 in_1 n_0 VDD VSS / CLKINVX1
.ENDS delay1_4_384

*******************************************************************************
* MODULE: delay1_4_385
*******************************************************************************
.SUBCKT delay1_4_385 clk res in_0 in_1 in_2 in_3 out_0 out_1 out_2 out_3 VDD VSS
Xout_reg_3 clk n_7 out_3 VDD VSS / DFFQX1
Xout_reg_2 clk n_4 out_2 VDD VSS / DFFQX1
Xout_reg_0 clk n_6 out_0 VDD VSS / DFFQX1
Xout_reg_1 clk n_5 out_1 VDD VSS / DFFQX1
Xg7__1617 res n_1 n_7 VDD VSS / NOR2X1
Xg8__2802 res n_2 n_6 VDD VSS / NOR2X1
Xg9__1705 res n_0 n_5 VDD VSS / NOR2X1
Xg10__5122 res n_3 n_4 VDD VSS / NOR2X1
Xg11 in_2 n_3 VDD VSS / CLKINVX1
Xg12 in_0 n_2 VDD VSS / CLKINVX1
Xg13 in_3 n_1 VDD VSS / CLKINVX1
Xg14 in_1 n_0 VDD VSS / CLKINVX1
.ENDS delay1_4_385

*******************************************************************************
* MODULE: delay1_4_386
*******************************************************************************
.SUBCKT delay1_4_386 clk res in_0 in_1 in_2 in_3 out_0 out_1 out_2 out_3 VDD VSS
Xout_reg_3 clk n_7 out_3 VDD VSS / DFFQX1
Xout_reg_2 clk n_4 out_2 VDD VSS / DFFQX1
Xout_reg_0 clk n_6 out_0 VDD VSS / DFFQX1
Xout_reg_1 clk n_5 out_1 VDD VSS / DFFQX1
Xg7__5115 res n_1 n_7 VDD VSS / NOR2X1
Xg8__7482 res n_2 n_6 VDD VSS / NOR2X1
Xg9__4733 res n_0 n_5 VDD VSS / NOR2X1
Xg10__6161 res n_3 n_4 VDD VSS / NOR2X1
Xg11 in_2 n_3 VDD VSS / CLKINVX1
Xg12 in_0 n_2 VDD VSS / CLKINVX1
Xg13 in_3 n_1 VDD VSS / CLKINVX1
Xg14 in_1 n_0 VDD VSS / CLKINVX1
.ENDS delay1_4_386

*******************************************************************************
* MODULE: delay1_4_387
*******************************************************************************
.SUBCKT delay1_4_387 clk res in_0 in_1 in_2 in_3 out_0 out_1 out_2 out_3 VDD VSS
Xout_reg_3 clk n_7 out_3 VDD VSS / DFFQX1
Xout_reg_2 clk n_4 out_2 VDD VSS / DFFQX1
Xout_reg_0 clk n_6 out_0 VDD VSS / DFFQX1
Xout_reg_1 clk n_5 out_1 VDD VSS / DFFQX1
Xg7__8428 res n_1 n_7 VDD VSS / NOR2X1
Xg8__5526 res n_2 n_6 VDD VSS / NOR2X1
Xg9__6783 res n_0 n_5 VDD VSS / NOR2X1
Xg10__3680 res n_3 n_4 VDD VSS / NOR2X1
Xg11 in_2 n_3 VDD VSS / CLKINVX1
Xg12 in_0 n_2 VDD VSS / CLKINVX1
Xg13 in_3 n_1 VDD VSS / CLKINVX1
Xg14 in_1 n_0 VDD VSS / CLKINVX1
.ENDS delay1_4_387

*******************************************************************************
* MODULE: delay1_4_388
*******************************************************************************
.SUBCKT delay1_4_388 clk res in_0 in_1 in_2 in_3 out_0 out_1 out_2 out_3 VDD VSS
Xout_reg_3 clk n_7 out_3 VDD VSS / DFFQX1
Xout_reg_2 clk n_4 out_2 VDD VSS / DFFQX1
Xout_reg_0 clk n_6 out_0 VDD VSS / DFFQX1
Xout_reg_1 clk n_5 out_1 VDD VSS / DFFQX1
Xg7__8246 res n_1 n_7 VDD VSS / NOR2X1
Xg8__7098 res n_2 n_6 VDD VSS / NOR2X1
Xg9__6131 res n_0 n_5 VDD VSS / NOR2X1
Xg10__1881 res n_3 n_4 VDD VSS / NOR2X1
Xg11 in_2 n_3 VDD VSS / CLKINVX1
Xg12 in_0 n_2 VDD VSS / CLKINVX1
Xg13 in_3 n_1 VDD VSS / CLKINVX1
Xg14 in_1 n_0 VDD VSS / CLKINVX1
.ENDS delay1_4_388

*******************************************************************************
* MODULE: delay1_4_389
*******************************************************************************
.SUBCKT delay1_4_389 clk res in_0 in_1 in_2 in_3 out_0 out_1 out_2 out_3 VDD VSS
Xout_reg_3 clk n_7 out_3 VDD VSS / DFFQX1
Xout_reg_2 clk n_4 out_2 VDD VSS / DFFQX1
Xout_reg_0 clk n_6 out_0 VDD VSS / DFFQX1
Xout_reg_1 clk n_5 out_1 VDD VSS / DFFQX1
Xg7__2398 res n_1 n_7 VDD VSS / NOR2X1
Xg8__5107 res n_2 n_6 VDD VSS / NOR2X1
Xg9__6260 res n_0 n_5 VDD VSS / NOR2X1
Xg10__4319 res n_3 n_4 VDD VSS / NOR2X1
Xg11 in_2 n_3 VDD VSS / CLKINVX1
Xg12 in_0 n_2 VDD VSS / CLKINVX1
Xg13 in_3 n_1 VDD VSS / CLKINVX1
Xg14 in_1 n_0 VDD VSS / CLKINVX1
.ENDS delay1_4_389

*******************************************************************************
* MODULE: delay1_4_390
*******************************************************************************
.SUBCKT delay1_4_390 clk res in_0 in_1 in_2 in_3 out_0 out_1 out_2 out_3 VDD VSS
Xout_reg_3 clk n_7 out_3 VDD VSS / DFFQX1
Xout_reg_2 clk n_4 out_2 VDD VSS / DFFQX1
Xout_reg_0 clk n_6 out_0 VDD VSS / DFFQX1
Xout_reg_1 clk n_5 out_1 VDD VSS / DFFQX1
Xg7__9315 res n_1 n_7 VDD VSS / NOR2X1
Xg8__9945 res n_2 n_6 VDD VSS / NOR2X1
Xg9__2883 res n_0 n_5 VDD VSS / NOR2X1
Xg10__2346 res n_3 n_4 VDD VSS / NOR2X1
Xg11 in_2 n_3 VDD VSS / CLKINVX1
Xg12 in_0 n_2 VDD VSS / CLKINVX1
Xg13 in_3 n_1 VDD VSS / CLKINVX1
Xg14 in_1 n_0 VDD VSS / CLKINVX1
.ENDS delay1_4_390

*******************************************************************************
* MODULE: delay1_4_391
*******************************************************************************
.SUBCKT delay1_4_391 clk res in_0 in_1 in_2 in_3 out_0 out_1 out_2 out_3 VDD VSS
Xout_reg_3 clk n_7 out_3 VDD VSS / DFFQX1
Xout_reg_2 clk n_4 out_2 VDD VSS / DFFQX1
Xout_reg_0 clk n_6 out_0 VDD VSS / DFFQX1
Xout_reg_1 clk n_5 out_1 VDD VSS / DFFQX1
Xg7__5115 res n_1 n_7 VDD VSS / NOR2X1
Xg8__7482 res n_2 n_6 VDD VSS / NOR2X1
Xg9__4733 res n_0 n_5 VDD VSS / NOR2X1
Xg10__6161 res n_3 n_4 VDD VSS / NOR2X1
Xg11 in_2 n_3 VDD VSS / CLKINVX1
Xg12 in_0 n_2 VDD VSS / CLKINVX1
Xg13 in_3 n_1 VDD VSS / CLKINVX1
Xg14 in_1 n_0 VDD VSS / CLKINVX1
.ENDS delay1_4_391

*******************************************************************************
* MODULE: delay1_4_392
*******************************************************************************
.SUBCKT delay1_4_392 clk res in_0 in_1 in_2 in_3 out_0 out_1 out_2 out_3 VDD VSS
Xout_reg_3 clk n_7 out_3 VDD VSS / DFFQX1
Xout_reg_2 clk n_4 out_2 VDD VSS / DFFQX1
Xout_reg_0 clk n_6 out_0 VDD VSS / DFFQX1
Xout_reg_1 clk n_5 out_1 VDD VSS / DFFQX1
Xg7__6131 res n_1 n_7 VDD VSS / NOR2X1
Xg8__1881 res n_2 n_6 VDD VSS / NOR2X1
Xg9__5115 res n_0 n_5 VDD VSS / NOR2X1
Xg10__7482 res n_3 n_4 VDD VSS / NOR2X1
Xg11 in_2 n_3 VDD VSS / CLKINVX1
Xg12 in_0 n_2 VDD VSS / CLKINVX1
Xg13 in_3 n_1 VDD VSS / CLKINVX1
Xg14 in_1 n_0 VDD VSS / CLKINVX1
.ENDS delay1_4_392

*******************************************************************************
* MODULE: delay1_4_393
*******************************************************************************
.SUBCKT delay1_4_393 clk res in_0 in_1 in_2 in_3 out_0 out_1 out_2 out_3 VDD VSS
Xout_reg_3 clk n_7 out_3 VDD VSS / DFFQX1
Xout_reg_2 clk n_4 out_2 VDD VSS / DFFQX1
Xout_reg_0 clk n_6 out_0 VDD VSS / DFFQX1
Xout_reg_1 clk n_5 out_1 VDD VSS / DFFQX1
Xg7__7410 res n_1 n_7 VDD VSS / NOR2X1
Xg8__6417 res n_2 n_6 VDD VSS / NOR2X1
Xg9__5477 res n_0 n_5 VDD VSS / NOR2X1
Xg10__2398 res n_3 n_4 VDD VSS / NOR2X1
Xg11 in_2 n_3 VDD VSS / CLKINVX1
Xg12 in_0 n_2 VDD VSS / CLKINVX1
Xg13 in_3 n_1 VDD VSS / CLKINVX1
Xg14 in_1 n_0 VDD VSS / CLKINVX1
.ENDS delay1_4_393

*******************************************************************************
* MODULE: delay1_4_394
*******************************************************************************
.SUBCKT delay1_4_394 clk res in_0 in_1 in_2 in_3 out_0 out_1 out_2 out_3 VDD VSS
Xout_reg_3 clk n_7 out_3 VDD VSS / DFFQX1
Xout_reg_2 clk n_4 out_2 VDD VSS / DFFQX1
Xout_reg_0 clk n_6 out_0 VDD VSS / DFFQX1
Xout_reg_1 clk n_5 out_1 VDD VSS / DFFQX1
Xg7__1705 n_1 res n_7 VDD VSS / NOR2X1
Xg8__5122 n_2 res n_6 VDD VSS / NOR2X1
Xg9__8246 n_0 res n_5 VDD VSS / NOR2X1
Xg10__7098 n_3 res n_4 VDD VSS / NOR2X1
Xg11 in_2 n_3 VDD VSS / CLKINVX1
Xg12 in_0 n_2 VDD VSS / CLKINVX1
Xg13 in_3 n_1 VDD VSS / CLKINVX1
Xg14 in_1 n_0 VDD VSS / CLKINVX1
.ENDS delay1_4_394

*******************************************************************************
* MODULE: delay1_4_395
*******************************************************************************
.SUBCKT delay1_4_395 clk res in_0 in_1 in_2 in_3 out_0 out_1 out_2 out_3 VDD VSS
Xout_reg_3 clk n_7 out_3 VDD VSS / DFFQX1
Xout_reg_2 clk n_4 out_2 VDD VSS / DFFQX1
Xout_reg_0 clk n_6 out_0 VDD VSS / DFFQX1
Xout_reg_1 clk n_5 out_1 VDD VSS / DFFQX1
Xg7__9945 n_1 res n_7 VDD VSS / NOR2X1
Xg8__2883 n_2 res n_6 VDD VSS / NOR2X1
Xg9__2346 n_0 res n_5 VDD VSS / NOR2X1
Xg10__1666 n_3 res n_4 VDD VSS / NOR2X1
Xg11 in_2 n_3 VDD VSS / CLKINVX1
Xg12 in_0 n_2 VDD VSS / CLKINVX1
Xg13 in_3 n_1 VDD VSS / CLKINVX1
Xg14 in_1 n_0 VDD VSS / CLKINVX1
.ENDS delay1_4_395

*******************************************************************************
* MODULE: dadz4
*******************************************************************************
.SUBCKT dadz4 clk res a_0 a_1 a_2 a_3 dadz_0 dadz_1 dadz_2 dadz_3 VDD VSS
Xdadz_reg_0 clk n_7 dadz_0 VDD VSS / DFFQX1
Xdadz_reg_1 clk n_6 dadz_1 VDD VSS / DFFQX1
Xg163__8246 res n_5 n_7 VDD VSS / NOR2X1
Xg164__7098 res n_11 n_6 VDD VSS / NOR2X1
Xg165__6131 a_1 n_2 n_5 VDD VSS / CLKXOR2X1
Xg168__7482 a_2 a_0 n_2 VDD VSS / NAND2X1
Xg2 n_10 a_2 n_11 VDD VSS / NAND2X1
Xg3 a_0 a_1 n_10 VDD VSS / NOR2X1
.ENDS dadz4

*******************************************************************************
* MODULE: dadz4_38
*******************************************************************************
.SUBCKT dadz4_38 clk res a_0 a_1 a_2 a_3 dadz_0 dadz_1 dadz_2 dadz_3 VDD VSS
Xdadz_reg_0 clk n_7 dadz_0 VDD VSS / DFFQX1
Xdadz_reg_1 clk n_6 dadz_1 VDD VSS / DFFQX1
Xg163__6783 res n_5 n_7 VDD VSS / NOR2X1
Xg164__3680 res n_11 n_6 VDD VSS / NOR2X1
Xg165__1617 a_1 n_2 n_5 VDD VSS / CLKXOR2X1
Xg168__5122 a_0 a_2 n_2 VDD VSS / NAND2X1
Xg2 n_10 a_2 n_11 VDD VSS / NAND2X1
Xg3 a_0 a_1 n_10 VDD VSS / NOR2X1
.ENDS dadz4_38

*******************************************************************************
* MODULE: dadz4_39
*******************************************************************************
.SUBCKT dadz4_39 clk res a_0 a_1 a_2 a_3 dadz_0 dadz_1 dadz_2 dadz_3 VDD VSS
Xdadz_reg_0 clk n_7 dadz_0 VDD VSS / DFFQX1
Xdadz_reg_1 clk n_6 dadz_1 VDD VSS / DFFQX1
Xg163__2398 res n_5 n_7 VDD VSS / NOR2X1
Xg164__5107 res n_11 n_6 VDD VSS / NOR2X1
Xg165__6260 a_1 n_2 n_5 VDD VSS / CLKXOR2X1
Xg168__5526 a_0 a_2 n_2 VDD VSS / NAND2X1
Xg2 n_10 a_2 n_11 VDD VSS / NAND2X1
Xg3 a_0 a_1 n_10 VDD VSS / NOR2X1
.ENDS dadz4_39

*******************************************************************************
* MODULE: delta3_4
*******************************************************************************
.SUBCKT delta3_4 clk res a3_0 a3_1 a3_2 a3_3 t_0 t_1 t_2 t_3 dadz_0 dadz_1 dadz_2 dadz_3 delta_0 delta_1 delta_2 delta_3 VDD VSS
Xdelta_reg_0 clk n_93 delta_0 VDD VSS / DFFQX1
Xg1030__9315 res n_92 n_93 VDD VSS / NOR2X1
Xdelta_reg_1 clk n_90 delta_1 VDD VSS / DFFQX1
Xg1032__9945 n_91 n_81 n_92 VDD VSS / AND2X1
Xdelta_reg_2 clk n_89 delta_2 VDD VSS / DFFQX1
Xg1034__2883 n_75 n_88 n_91 VDD VSS / NOR2X1
Xg1035__2346 res n_87 n_90 VDD VSS / NOR2X1
Xdelta_reg_3 clk n_86 delta_3 VDD VSS / DFFQX1
Xg1037__1666 res n_85 n_89 VDD VSS / NOR2X1
Xg1038__7410 n_84 n_18 n_88 VDD VSS / NOR2X1
Xg1039__6417 n_76 n_83 n_87 VDD VSS / NOR2X1
Xg1040__5477 res n_78 n_86 VDD VSS / NOR2X1
Xg1041__2398 n_82 n_22 n_85 VDD VSS / NOR2X1
Xg1042__5107 n_79 n_24 n_84 VDD VSS / NOR2X1
Xg1043__6260 n_77 n_80 n_83 VDD VSS / NAND2X1
Xg1044__4319 n_54 n_67 n_82 VDD VSS / NAND2X1
Xg1045__8428 n_65 n_62 n_81 VDD VSS / NOR2X1
Xg1046__5526 n_70 dadz_0 n_80 VDD VSS / NAND2X1
Xg1047__6783 n_66 n_40 n_79 VDD VSS / NAND2X1
Xg1048__3680 n_68 n_8 n_78 VDD VSS / NOR2X1
Xg1049__1617 n_73 n_69 n_77 VDD VSS / NOR2X1
Xg1050__2802 n_64 n_74 n_76 VDD VSS / NAND2X1
Xg1051__1705 n_71 n_72 n_75 VDD VSS / NAND2X1
Xg1052__5122 n_60 n_8 n_74 VDD VSS / NAND2X1
Xg1053__8246 n_63 a3_3 n_73 VDD VSS / NOR2X1
Xg1054__7098 n_55 n_1 n_72 VDD VSS / NAND2X1
Xg1055__6131 n_58 dadz_1 n_71 VDD VSS / NAND2X1
Xg1056__1881 n_24 n_57 n_70 VDD VSS / OR2X1
Xg1057__5115 n_49 n_0 n_69 VDD VSS / NOR2X1
Xg1058__7482 n_56 n_7 n_68 VDD VSS / NAND2X1
Xg1059__4733 n_53 n_38 n_67 VDD VSS / NOR2X1
Xg1060__6161 n_50 n_32 n_66 VDD VSS / NOR2X1
Xg1061__9315 n_51 n_52 n_65 VDD VSS / NAND2X1
Xg1062__9945 n_61 n_59 n_64 VDD VSS / NOR2X1
Xg1063__2883 n_48 n_16 n_63 VDD VSS / NAND2X1
Xg1064__2346 n_43 dadz_0 n_62 VDD VSS / NOR2X1
Xg1065__1666 n_45 n_1 n_61 VDD VSS / AND2X1
Xg1066__7410 n_46 dadz_1 n_60 VDD VSS / NAND2X1
Xg1067__6417 n_25 n_48 n_59 VDD VSS / NOR2X1
Xg1068__5477 n_47 a3_1 n_58 VDD VSS / AND2X1
Xg1069__2398 n_36 n_1 n_57 VDD VSS / NOR2X1
Xg1070__5107 n_48 n_5 n_56 VDD VSS / NAND2X1
Xg1071__6260 n_41 n_15 n_55 VDD VSS / NOR2X1
Xg1072__4319 n_44 n_25 n_54 VDD VSS / AND2X1
Xg1073__8428 n_48 n_21 n_53 VDD VSS / AND2X1
Xg1074__5526 n_35 n_22 n_52 VDD VSS / NAND2X1
Xg1075__6783 n_37 n_10 n_51 VDD VSS / NAND2X1
Xg1076__3680 n_39 n_3 n_50 VDD VSS / NOR2X1
Xg1077__1617 n_42 n_22 n_49 VDD VSS / NOR2X1
Xg1078__2802 n_29 n_9 n_47 VDD VSS / NOR2X1
Xg1079__1705 n_11 n_26 n_46 VDD VSS / NOR2X1
Xg1080__5122 n_33 a3_0 n_45 VDD VSS / NOR2X1
Xg1081__8246 n_34 a3_0 n_44 VDD VSS / NAND2X1
Xg1082__7098 n_15 n_30 n_43 VDD VSS / OR2X1
Xg1083__6131 n_20 n_4 n_42 VDD VSS / NOR2X1
Xg1084__1881 n_27 t_0 n_48 VDD VSS / AND2X1
Xg1085__5115 a3_3 n_2 n_17 n_41 VDD VSS / MX2X1
Xg1086__7482 n_31 t_0 n_40 VDD VSS / NAND2X1
Xg1087__4733 n_26 n_4 n_39 VDD VSS / NAND2X1
Xg1088__6161 n_23 n_8 n_38 VDD VSS / AND2X1
Xg1089__9315 n_19 n_33 n_37 VDD VSS / NAND2X1
Xg1090__9945 n_28 n_11 n_36 VDD VSS / NOR2X1
Xg1091__2883 n_6 n_23 n_35 VDD VSS / OR2X1
Xg1092 n_33 n_34 VDD VSS / CLKINVX1
Xg1093__2346 n_17 n_12 n_32 VDD VSS / AND2X1
Xg1094__1666 n_15 n_1 n_31 VDD VSS / AND2X1
Xg1095__7410 n_10 t_0 n_30 VDD VSS / AND2X1
Xg1096__6417 n_11 n_13 n_29 VDD VSS / NOR2X1
Xg1097__5477 n_15 t_0 n_28 VDD VSS / NOR2X1
Xg1098__2398 n_10 a3_2 n_27 VDD VSS / NAND2X1
Xg1099__5107 n_8 a3_2 n_33 VDD VSS / NAND2X1
Xg1100__6260 n_18 n_14 n_21 VDD VSS / NAND2X1
Xg1101__4319 n_10 n_18 n_20 VDD VSS / OR2X1
Xg1102__8428 n_11 n_16 n_19 VDD VSS / NAND2X1
Xg1103__5526 n_10 n_0 n_26 VDD VSS / AND2X1
Xg1104__6783 n_16 a3_3 n_25 VDD VSS / NAND2X1
Xg1105__3680 n_11 n_3 n_24 VDD VSS / AND2X1
Xg1106__1617 n_3 n_12 n_23 VDD VSS / OR2X1
Xg1107__2802 n_9 t_0 n_22 VDD VSS / NOR2X1
Xg1108__1705 n_2 dadz_1 n_14 VDD VSS / NAND2X1
Xg1109__5122 a3_2 a3_0 n_13 VDD VSS / NOR2X1
Xg1110__8246 n_2 dadz_0 n_18 VDD VSS / NAND2X1
Xg1111__7098 n_4 a3_0 n_17 VDD VSS / NOR2X1
Xg1112__6131 n_3 dadz_0 n_16 VDD VSS / NOR2X1
Xg1113__1881 a3_2 dadz_1 n_15 VDD VSS / NAND2X1
Xg1114 n_9 n_8 VDD VSS / CLKINVX1
Xg1115__5115 dadz_1 a3_3 n_7 VDD VSS / NAND2X1
Xg1116__7482 a3_2 a3_1 n_6 VDD VSS / NOR2X1
Xg1117__4733 dadz_1 dadz_0 n_5 VDD VSS / OR2X1
Xg1118__6161 n_0 n_1 n_12 VDD VSS / NOR2X1
Xg1119__9315 n_4 a3_2 n_11 VDD VSS / NOR2X1
Xg1120__9945 a3_1 a3_0 n_10 VDD VSS / AND2X1
Xg1121__2883 dadz_0 a3_3 n_9 VDD VSS / NAND2X1
Xg1122 t_0 n_4 VDD VSS / CLKINVX1
Xg1123 dadz_1 n_3 VDD VSS / CLKINVX1
Xg1124 a3_3 n_2 VDD VSS / CLKINVX1
Xg1125 a3_1 n_1 VDD VSS / CLKINVX1
Xg1126 a3_2 n_0 VDD VSS / CLKINVX1
.ENDS delta3_4

*******************************************************************************
* MODULE: delta2_4
*******************************************************************************
.SUBCKT delta2_4 clk res dadz_0 dadz_1 dadz_2 dadz_3 w3_0 w3_1 w3_2 w3_3 delta3_0 delta3_1 delta3_2 delta3_3 delta_0 delta_1 delta_2 delta_3 VDD VSS
Xdelta_reg_0 clk n_88 delta_0 VDD VSS / DFFQX1
Xdelta_reg_1 clk n_87 delta_1 VDD VSS / DFFQX1
Xg739__1666 n_86 res n_88 VDD VSS / NOR2X1
Xdelta_reg_2 clk n_84 delta_2 VDD VSS / DFFQX1
Xg741__7410 n_85 res n_87 VDD VSS / NOR2X1
Xg742__6417 n_74 n_81 n_86 VDD VSS / XNOR2X1
Xg743__5477 n_80 n_106 n_85 VDD VSS / AND2X1
Xg744__2398 n_82 res n_84 VDD VSS / NOR2X1
Xg746__6260 n_78 n_73 n_82 VDD VSS / AND2X1
Xg747__4319 n_67 n_76 n_81 VDD VSS / CLKXOR2X1
Xg748__8428 n_76 n_67 n_80 VDD VSS / NAND2X1
Xg750__6783 n_76 n_74 n_78 VDD VSS / NAND2X1
Xg752__1617 n_65 n_71 n_76 VDD VSS / CLKXOR2X1
Xg754__2802 n_72 n_54 n_74 VDD VSS / NOR2X1
Xg755__1705 n_65 n_71 n_73 VDD VSS / OR2X1
Xg756__5122 n_104 n_53 n_72 VDD VSS / NAND2X1
Xg757__8246 n_68 dadz_0 n_71 VDD VSS / NAND2X1
Xg760__6131 n_45 n_64 n_68 VDD VSS / CLKXOR2X1
Xg761__1881 n_65 n_61 n_67 VDD VSS / NOR2X1
Xg763__7482 n_62 dadz_1 n_65 VDD VSS / NAND2X1
Xg764__4733 n_60 n_49 n_64 VDD VSS / NAND2X1
Xg766__6161 n_51 n_59 n_62 VDD VSS / CLKXOR2X1
Xg767__9315 n_58 dadz_0 n_61 VDD VSS / NAND2X1
Xg768__9945 n_59 n_47 n_60 VDD VSS / NAND2X1
Xg769__2883 n_57 n_0 n_59 VDD VSS / NAND2X1
Xg770__2346 n_55 n_56 n_58 VDD VSS / XNOR2X1
Xg771__1666 n_56 n_52 n_57 VDD VSS / NAND2X1
Xg772__7410 n_48 n_54 n_56 VDD VSS / OR2X1
Xg773__6417 n_52 n_0 n_55 VDD VSS / NAND2X1
Xg774__5477 n_50 n_40 n_53 VDD VSS / NAND2X1
Xg775__2398 n_50 n_40 n_54 VDD VSS / NOR2X1
Xg776__5107 n_46 n_43 n_52 VDD VSS / NAND2X1
Xg777__6260 n_47 n_49 n_51 VDD VSS / AND2X1
Xg779__4319 n_41 n_22 n_48 VDD VSS / AND2X1
Xg780__8428 n_41 n_22 n_50 VDD VSS / NOR2X1
Xg781__5526 n_44 n_42 n_49 VDD VSS / NAND2X1
Xg783__6783 n_42 n_44 n_47 VDD VSS / OR2X1
Xg784__3680 n_1 n_37 n_45 VDD VSS / XNOR2X1
Xg785__1617 n_31 n_36 n_46 VDD VSS / CLKXOR2X1
Xg787__2802 n_39 n_33 n_44 VDD VSS / NAND2X1
Xg788__1705 n_38 n_25 n_43 VDD VSS / NOR2X1
Xg789__5122 n_21 n_28 n_42 VDD VSS / XNOR2X1
Xg790__8246 n_29 n_30 n_41 VDD VSS / XNOR2X1
Xg791__7098 n_31 n_34 n_39 VDD VSS / OR2X1
Xg792__6131 n_2 n_35 n_40 VDD VSS / OR2X1
Xg793__1881 n_30 n_18 n_38 VDD VSS / AND2X1
Xg794__5115 n_32 n_20 n_37 VDD VSS / NAND2X1
Xg795__7482 n_9 n_26 n_36 VDD VSS / XNOR2X1
Xg796__4733 n_19 n_6 n_35 VDD VSS / NOR2X1
Xg797__6161 n_27 n_9 n_34 VDD VSS / NOR2X1
Xg798__9315 n_27 n_9 n_33 VDD VSS / NAND2X1
Xg799__9945 n_21 n_23 n_32 VDD VSS / OR2X1
Xg800__2883 n_11 n_4 n_29 VDD VSS / CLKXOR2X1
Xg801__2346 n_3 n_10 n_28 VDD VSS / CLKXOR2X1
Xg802__1666 n_21 n_24 n_31 VDD VSS / NOR2X1
Xg803__7410 n_13 n_5 n_30 VDD VSS / XNOR2X1
Xg804 n_26 n_27 VDD VSS / CLKINVX1
Xg805__6417 n_4 n_12 n_25 VDD VSS / NOR2X1
Xg806__5477 n_7 n_15 n_24 VDD VSS / NOR2X1
Xg807__2398 n_10 n_3 n_23 VDD VSS / NOR2X1
Xg808__5107 n_14 n_5 n_26 VDD VSS / NAND2X1
Xg809__6260 n_10 n_3 n_20 VDD VSS / NAND2X1
Xg810__4319 n_16 n_8 n_19 VDD VSS / NAND2X1
Xg811__8428 n_12 n_4 n_18 VDD VSS / NAND2X1
Xg812__5526 n_17 n_6 n_22 VDD VSS / AND2X1
Xg813__6783 n_7 n_15 n_21 VDD VSS / AND2X1
Xg814 n_16 n_17 VDD VSS / CLKINVX1
Xg815 n_13 n_14 VDD VSS / CLKINVX1
Xg816 n_11 n_12 VDD VSS / CLKINVX1
Xg817__3680 delta3_0 w3_0 n_8 VDD VSS / NAND2X1
Xg818__1617 delta3_2 w3_0 n_16 VDD VSS / NAND2X1
Xg819__2802 delta3_2 w3_2 n_15 VDD VSS / NAND2X1
Xg820__1705 delta3_1 w3_2 n_13 VDD VSS / NAND2X1
Xg821__5122 delta3_3 w3_0 n_11 VDD VSS / NAND2X1
Xg822__8246 delta3_2 w3_3 n_10 VDD VSS / NAND2X1
Xg823__7098 delta3_3 w3_1 n_9 VDD VSS / NAND2X1
Xg824__6131 delta3_1 w3_1 n_2 VDD VSS / NAND2X1
Xg825__1881 delta3_1 w3_3 n_7 VDD VSS / AND2X1
Xg826__5115 delta3_3 w3_3 n_1 VDD VSS / NAND2X1
Xg827__7482 delta3_0 w3_2 n_6 VDD VSS / AND2X1
Xg828__4733 delta3_0 w3_3 n_5 VDD VSS / NAND2X1
Xg829__6161 delta3_2 w3_1 n_4 VDD VSS / NAND2X1
Xg830__9315 delta3_3 w3_2 n_3 VDD VSS / NAND2X1
Xg2__9945 n_46 n_43 n_0 VDD VSS / OR2X1
Xg3 n_68 n_73 n_101 VDD VSS / NAND2X1
Xg831 n_103 dadz_1 n_104 VDD VSS / AND2X1
Xg832 n_61 n_62 n_103 VDD VSS / NOR2X1
Xg833 n_105 dadz_1 n_106 VDD VSS / NAND2X1
Xg834 n_101 n_74 n_105 VDD VSS / NOR2X1
.ENDS delta2_4

*******************************************************************************
* MODULE: delta2_4_75
*******************************************************************************
.SUBCKT delta2_4_75 clk res dadz_0 dadz_1 dadz_2 dadz_3 w3_0 w3_1 w3_2 w3_3 delta3_0 delta3_1 delta3_2 delta3_3 delta_0 delta_1 delta_2 delta_3 VDD VSS
Xdelta_reg_0 clk n_88 delta_0 VDD VSS / DFFQX1
Xdelta_reg_1 clk n_87 delta_1 VDD VSS / DFFQX1
Xg739__2883 n_86 res n_88 VDD VSS / NOR2X1
Xdelta_reg_2 clk n_84 delta_2 VDD VSS / DFFQX1
Xg741__2346 n_85 res n_87 VDD VSS / NOR2X1
Xg742__1666 n_74 n_81 n_86 VDD VSS / XNOR2X1
Xg743__7410 n_80 n_106 n_85 VDD VSS / AND2X1
Xg744__6417 n_82 res n_84 VDD VSS / NOR2X1
Xg746__2398 n_78 n_73 n_82 VDD VSS / AND2X1
Xg747__5107 n_67 n_76 n_81 VDD VSS / CLKXOR2X1
Xg748__6260 n_76 n_67 n_80 VDD VSS / NAND2X1
Xg750__8428 n_76 n_74 n_78 VDD VSS / NAND2X1
Xg752__6783 n_65 n_71 n_76 VDD VSS / CLKXOR2X1
Xg754__3680 n_72 n_54 n_74 VDD VSS / NOR2X1
Xg755__1617 n_65 n_71 n_73 VDD VSS / OR2X1
Xg756__2802 n_104 n_53 n_72 VDD VSS / NAND2X1
Xg757__1705 n_68 dadz_0 n_71 VDD VSS / NAND2X1
Xg760__8246 n_45 n_64 n_68 VDD VSS / CLKXOR2X1
Xg761__7098 n_65 n_61 n_67 VDD VSS / NOR2X1
Xg763__1881 n_62 dadz_1 n_65 VDD VSS / NAND2X1
Xg764__5115 n_60 n_49 n_64 VDD VSS / NAND2X1
Xg766__7482 n_51 n_59 n_62 VDD VSS / CLKXOR2X1
Xg767__4733 n_58 dadz_0 n_61 VDD VSS / NAND2X1
Xg768__6161 n_59 n_47 n_60 VDD VSS / NAND2X1
Xg769__9315 n_57 n_0 n_59 VDD VSS / NAND2X1
Xg770__9945 n_55 n_56 n_58 VDD VSS / XNOR2X1
Xg771__2883 n_56 n_52 n_57 VDD VSS / NAND2X1
Xg772__2346 n_48 n_54 n_56 VDD VSS / OR2X1
Xg773__1666 n_52 n_0 n_55 VDD VSS / NAND2X1
Xg774__7410 n_50 n_40 n_53 VDD VSS / NAND2X1
Xg775__6417 n_50 n_40 n_54 VDD VSS / NOR2X1
Xg776__5477 n_46 n_43 n_52 VDD VSS / NAND2X1
Xg777__2398 n_47 n_49 n_51 VDD VSS / AND2X1
Xg779__5107 n_41 n_22 n_48 VDD VSS / AND2X1
Xg780__6260 n_41 n_22 n_50 VDD VSS / NOR2X1
Xg781__4319 n_44 n_42 n_49 VDD VSS / NAND2X1
Xg783__8428 n_42 n_44 n_47 VDD VSS / OR2X1
Xg784__5526 n_1 n_37 n_45 VDD VSS / XNOR2X1
Xg785__6783 n_31 n_36 n_46 VDD VSS / CLKXOR2X1
Xg787__3680 n_39 n_33 n_44 VDD VSS / NAND2X1
Xg788__1617 n_38 n_25 n_43 VDD VSS / NOR2X1
Xg789__2802 n_21 n_28 n_42 VDD VSS / XNOR2X1
Xg790__1705 n_29 n_30 n_41 VDD VSS / XNOR2X1
Xg791__5122 n_31 n_34 n_39 VDD VSS / OR2X1
Xg792__8246 n_2 n_35 n_40 VDD VSS / OR2X1
Xg793__7098 n_30 n_18 n_38 VDD VSS / AND2X1
Xg794__6131 n_32 n_20 n_37 VDD VSS / NAND2X1
Xg795__1881 n_9 n_26 n_36 VDD VSS / XNOR2X1
Xg796__5115 n_19 n_6 n_35 VDD VSS / NOR2X1
Xg797__7482 n_27 n_9 n_34 VDD VSS / NOR2X1
Xg798__4733 n_27 n_9 n_33 VDD VSS / NAND2X1
Xg799__6161 n_21 n_23 n_32 VDD VSS / OR2X1
Xg800__9315 n_11 n_4 n_29 VDD VSS / CLKXOR2X1
Xg801__9945 n_3 n_10 n_28 VDD VSS / CLKXOR2X1
Xg802__2883 n_21 n_24 n_31 VDD VSS / NOR2X1
Xg803__2346 n_13 n_5 n_30 VDD VSS / XNOR2X1
Xg804 n_26 n_27 VDD VSS / CLKINVX1
Xg805__1666 n_4 n_12 n_25 VDD VSS / NOR2X1
Xg806__7410 n_7 n_15 n_24 VDD VSS / NOR2X1
Xg807__6417 n_10 n_3 n_23 VDD VSS / NOR2X1
Xg808__5477 n_14 n_5 n_26 VDD VSS / NAND2X1
Xg809__2398 n_10 n_3 n_20 VDD VSS / NAND2X1
Xg810__5107 n_16 n_8 n_19 VDD VSS / NAND2X1
Xg811__6260 n_12 n_4 n_18 VDD VSS / NAND2X1
Xg812__4319 n_17 n_6 n_22 VDD VSS / AND2X1
Xg813__8428 n_7 n_15 n_21 VDD VSS / AND2X1
Xg814 n_16 n_17 VDD VSS / CLKINVX1
Xg815 n_13 n_14 VDD VSS / CLKINVX1
Xg816 n_11 n_12 VDD VSS / CLKINVX1
Xg817__5526 delta3_0 w3_0 n_8 VDD VSS / NAND2X1
Xg818__6783 delta3_2 w3_0 n_16 VDD VSS / NAND2X1
Xg819__3680 delta3_2 w3_2 n_15 VDD VSS / NAND2X1
Xg820__1617 delta3_1 w3_2 n_13 VDD VSS / NAND2X1
Xg821__2802 delta3_3 w3_0 n_11 VDD VSS / NAND2X1
Xg822__1705 delta3_2 w3_3 n_10 VDD VSS / NAND2X1
Xg823__5122 delta3_3 w3_1 n_9 VDD VSS / NAND2X1
Xg824__8246 delta3_1 w3_1 n_2 VDD VSS / NAND2X1
Xg825__7098 delta3_1 w3_3 n_7 VDD VSS / AND2X1
Xg826__6131 delta3_3 w3_3 n_1 VDD VSS / NAND2X1
Xg827__1881 delta3_0 w3_2 n_6 VDD VSS / AND2X1
Xg828__5115 delta3_0 w3_3 n_5 VDD VSS / NAND2X1
Xg829__7482 delta3_2 w3_1 n_4 VDD VSS / NAND2X1
Xg830__4733 delta3_3 w3_2 n_3 VDD VSS / NAND2X1
Xg2__6161 n_46 n_43 n_0 VDD VSS / OR2X1
Xg3 n_68 n_73 n_101 VDD VSS / NAND2X1
Xg831 n_103 dadz_1 n_104 VDD VSS / AND2X1
Xg832 n_61 n_62 n_103 VDD VSS / NOR2X1
Xg833 n_105 dadz_1 n_106 VDD VSS / NAND2X1
Xg834 n_101 n_74 n_105 VDD VSS / NOR2X1
.ENDS delta2_4_75

*******************************************************************************
* MODULE: dw4
*******************************************************************************
.SUBCKT dw4 clk res err_0 err_1 err_2 err_3 inp_0 inp_1 inp_2 inp_3 dw_0 dw_1 dw_2 dw_3 VDD VSS
Xdw_reg_3 clk n_69 dw_3 VDD VSS / DFFQX1
Xg733__8246 res n_68 n_69 VDD VSS / NOR2X1
Xdw_reg_2 clk n_67 dw_2 VDD VSS / DFFQX1
Xg735__7098 n_45 n_65 n_68 VDD VSS / CLKXOR2X1
Xg736__6131 res n_66 n_67 VDD VSS / NOR2X1
Xdw_reg_1 clk n_64 dw_1 VDD VSS / DFFQX1
Xg738__1881 n_52 n_61 n_66 VDD VSS / XNOR2X1
Xg739__5115 n_63 n_48 n_65 VDD VSS / NAND2X1
Xdw_reg_0 clk n_62 dw_0 VDD VSS / DFFQX1
Xg741__7482 res n_60 n_64 VDD VSS / NOR2X1
Xg742__4733 n_61 n_47 n_63 VDD VSS / NAND2X1
Xg743__6161 res n_58 n_62 VDD VSS / NOR2X1
Xg744__9315 n_57 n_56 n_60 VDD VSS / XNOR2X1
Xg745__9945 n_59 n_0 n_61 VDD VSS / NAND2X1
Xg746__2883 n_57 n_53 n_59 VDD VSS / NAND2X1
Xg747__2346 n_43 n_54 n_58 VDD VSS / XNOR2X1
Xg748__1666 n_55 n_49 n_57 VDD VSS / NAND2X1
Xg749__7410 n_53 n_0 n_56 VDD VSS / AND2X1
Xg750__6417 n_43 n_50 n_55 VDD VSS / OR2X1
Xg751__5477 n_51 n_49 n_54 VDD VSS / NAND2X1
Xg752__2398 n_46 n_42 n_53 VDD VSS / NAND2X1
Xg753__5107 n_47 n_48 n_52 VDD VSS / AND2X1
Xg755 n_50 n_51 VDD VSS / CLKINVX1
Xg756__6260 n_40 n_26 n_50 VDD VSS / NOR2X1
Xg757__4319 n_40 n_26 n_49 VDD VSS / NAND2X1
Xg758__8428 n_44 n_41 n_48 VDD VSS / NAND2X1
Xg760__5526 n_41 n_44 n_47 VDD VSS / OR2X1
Xg761__6783 n_1 n_36 n_45 VDD VSS / XNOR2X1
Xg762__3680 n_30 n_35 n_46 VDD VSS / CLKXOR2X1
Xg763__1617 n_39 n_32 n_44 VDD VSS / NAND2X1
Xg764__2802 n_38 inp_1 n_43 VDD VSS / NAND2X1
Xg766__1705 n_37 n_19 n_42 VDD VSS / NOR2X1
Xg767__5122 n_22 n_27 n_41 VDD VSS / CLKXOR2X1
Xg768__8246 n_28 n_29 n_40 VDD VSS / CLKXOR2X1
Xg769__7098 n_31 n_30 n_39 VDD VSS / NAND2X1
Xg770__6131 n_33 err_1 n_38 VDD VSS / AND2X1
Xg771__1881 n_29 n_21 n_37 VDD VSS / AND2X1
Xg772__5115 n_34 n_20 n_36 VDD VSS / NOR2X1
Xg773__7482 n_3 n_25 n_35 VDD VSS / XNOR2X1
Xg774__4733 n_22 n_24 n_34 VDD VSS / NOR2X1
Xg775__6161 n_23 n_15 n_33 VDD VSS / NAND2X1
Xg776__9315 n_25 n_3 n_32 VDD VSS / NAND2X1
Xg777__9945 n_3 n_25 n_31 VDD VSS / OR2X1
Xg778__2883 n_9 n_4 n_28 VDD VSS / XNOR2X1
Xg779__2346 n_5 n_11 n_27 VDD VSS / XNOR2X1
Xg780__1666 n_18 n_22 n_30 VDD VSS / OR2X1
Xg781__7410 n_12 n_13 n_29 VDD VSS / XNOR2X1
Xg782__6417 n_11 n_5 n_24 VDD VSS / NOR2X1
Xg783__5477 n_6 n_2 n_23 VDD VSS / AND2X1
Xg784__2398 n_6 n_15 n_26 VDD VSS / NOR2X1
Xg785__5107 n_12 n_14 n_25 VDD VSS / NOR2X1
Xg786__6260 n_10 n_4 n_21 VDD VSS / NAND2X1
Xg787__4319 n_11 n_5 n_20 VDD VSS / AND2X1
Xg788__8428 n_4 n_10 n_19 VDD VSS / NOR2X1
Xg789__5526 n_8 n_16 n_18 VDD VSS / NOR2X1
Xg790__6783 n_17 n_7 n_22 VDD VSS / NOR2X1
Xg791 n_16 n_17 VDD VSS / CLKINVX1
Xg792 n_13 n_14 VDD VSS / CLKINVX1
Xg793 n_9 n_10 VDD VSS / CLKINVX1
Xg794__3680 err_2 inp_2 n_16 VDD VSS / NAND2X1
Xg795__1617 err_0 inp_2 n_15 VDD VSS / NAND2X1
Xg796__2802 err_3 inp_0 n_13 VDD VSS / NAND2X1
Xg797__1705 err_2 inp_1 n_12 VDD VSS / NAND2X1
Xg798__5122 err_3 inp_2 n_11 VDD VSS / NAND2X1
Xg799__8246 err_0 inp_3 n_9 VDD VSS / NAND2X1
Xg800 n_7 n_8 VDD VSS / CLKINVX1
Xg801__7098 err_0 inp_0 n_2 VDD VSS / NAND2X1
Xg802__6131 err_3 inp_3 n_1 VDD VSS / NAND2X1
Xg803__1881 err_3 inp_1 n_7 VDD VSS / NAND2X1
Xg804__5115 err_2 inp_0 n_6 VDD VSS / NAND2X1
Xg805__7482 err_2 inp_3 n_5 VDD VSS / NAND2X1
Xg806__4733 err_1 inp_2 n_4 VDD VSS / NAND2X1
Xg807__6161 err_1 inp_3 n_3 VDD VSS / NAND2X1
Xg2__9315 n_46 n_42 n_0 VDD VSS / OR2X1
.ENDS dw4

*******************************************************************************
* MODULE: dw4_76
*******************************************************************************
.SUBCKT dw4_76 clk res err_0 err_1 err_2 err_3 inp_0 inp_1 inp_2 inp_3 dw_0 dw_1 dw_2 dw_3 VDD VSS
Xdw_reg_2 clk n_51 dw_2 VDD VSS / DFFQX1
Xg697__9945 res n_50 n_51 VDD VSS / NOR2X1
Xdw_reg_1 clk n_49 dw_1 VDD VSS / DFFQX1
Xg699__2883 n_37 n_46 n_50 VDD VSS / XNOR2X1
Xdw_reg_0 clk n_48 dw_0 VDD VSS / DFFQX1
Xg701__2346 res n_47 n_49 VDD VSS / NOR2X1
Xdw_reg_3 clk n_45 dw_3 VDD VSS / DFFQX1
Xg703__1666 res n_43 n_48 VDD VSS / NOR2X1
Xg704__7410 n_41 n_38 n_47 VDD VSS / XNOR2X1
Xg705__6417 n_44 n_31 n_46 VDD VSS / NAND2X1
Xg706__5477 res n_42 n_45 VDD VSS / NOR2X1
Xg707__2398 n_32 n_41 n_44 VDD VSS / OR2X1
Xg708__5107 n_28 n_36 n_43 VDD VSS / XNOR2X1
Xg709__6260 n_40 n_34 n_42 VDD VSS / AND2X1
Xg710__4319 n_39 n_35 n_41 VDD VSS / NOR2X1
Xg711__8428 n_31 inp_3 n_40 VDD VSS / NAND2X1
Xg712__5526 n_26 n_30 n_39 VDD VSS / AND2X1
Xg713__6783 n_31 n_33 n_38 VDD VSS / NAND2X1
Xg714__3680 n_24 n_29 inp_3 n_37 VDD VSS / MX2X1
Xg715__1617 n_22 n_26 n_36 VDD VSS / CLKXOR2X1
Xg716__2802 n_28 n_22 n_35 VDD VSS / NOR2X1
Xg717__1705 n_0 n_29 n_34 VDD VSS / OR2X1
Xg718 n_32 n_33 VDD VSS / CLKINVX1
Xg719__5122 n_22 n_28 n_30 VDD VSS / NAND2X1
Xg720__8246 n_27 n_23 n_32 VDD VSS / NOR2X1
Xg721__7098 n_27 n_23 n_31 VDD VSS / NAND2X1
Xg722__6131 n_24 err_2 n_29 VDD VSS / NAND2X1
Xg723__1881 n_25 err_1 n_28 VDD VSS / NAND2X1
Xg724__5115 n_3 n_18 n_27 VDD VSS / XNOR2X1
Xg725__7482 n_1 n_2 n_17 n_26 VDD VSS / MX2X1
Xg726__4733 n_21 inp_1 n_25 VDD VSS / AND2X1
Xg727__6161 n_20 n_12 n_24 VDD VSS / NOR2X1
Xg728__9315 n_19 n_14 n_23 VDD VSS / NAND2X1
Xg729__9945 n_16 n_8 n_21 VDD VSS / NOR2X1
Xg730__2883 n_13 n_2 n_20 VDD VSS / NOR2X1
Xg731__2346 n_15 err_0 n_22 VDD VSS / NAND2X1
Xg732__1666 n_11 n_2 n_19 VDD VSS / NAND2X1
Xg733__7410 n_1 n_2 n_6 n_18 VDD VSS / MX2X1
Xg734__6417 n_5 n_9 n_17 VDD VSS / CLKXOR2X1
Xg735__5477 n_7 inp_0 n_16 VDD VSS / NOR2X1
Xg736__2398 n_4 inp_0 n_15 VDD VSS / AND2X1
Xg737__5107 n_5 n_10 n_14 VDD VSS / NAND2X1
Xg738__6260 n_4 n_6 n_13 VDD VSS / NOR2X1
Xg739__4319 n_4 n_6 n_12 VDD VSS / AND2X1
Xg740__8428 n_10 n_5 n_11 VDD VSS / OR2X1
Xg741 n_9 n_10 VDD VSS / CLKINVX1
Xg742__5526 err_2 err_0 n_8 VDD VSS / NOR2X1
Xg743__6783 err_0 inp_2 n_7 VDD VSS / AND2X1
Xg744__3680 inp_2 err_1 n_9 VDD VSS / NAND2X1
Xg745 n_3 n_4 VDD VSS / CLKINVX1
Xg746 n_2 n_1 VDD VSS / CLKINVX1
Xg747__1617 err_1 inp_3 n_6 VDD VSS / NAND2X1
Xg748__2802 err_0 inp_3 n_5 VDD VSS / NAND2X1
Xg749__1705 err_2 inp_2 n_3 VDD VSS / NAND2X1
Xg750__5122 err_2 inp_1 n_2 VDD VSS / NAND2X1
Xg751 inp_3 n_0 VDD VSS / CLKINVX1
.ENDS dw4_76

*******************************************************************************
* MODULE: dw4_77
*******************************************************************************
.SUBCKT dw4_77 clk res err_0 err_1 err_2 err_3 inp_0 inp_1 inp_2 inp_3 dw_0 dw_1 dw_2 dw_3 VDD VSS
Xdw_reg_2 clk n_51 dw_2 VDD VSS / DFFQX1
Xg697__5122 res n_50 n_51 VDD VSS / NOR2X1
Xdw_reg_1 clk n_49 dw_1 VDD VSS / DFFQX1
Xg699__8246 n_37 n_46 n_50 VDD VSS / XNOR2X1
Xdw_reg_0 clk n_48 dw_0 VDD VSS / DFFQX1
Xg701__7098 res n_47 n_49 VDD VSS / NOR2X1
Xdw_reg_3 clk n_45 dw_3 VDD VSS / DFFQX1
Xg703__6131 res n_43 n_48 VDD VSS / NOR2X1
Xg704__1881 n_41 n_38 n_47 VDD VSS / XNOR2X1
Xg705__5115 n_44 n_31 n_46 VDD VSS / NAND2X1
Xg706__7482 res n_42 n_45 VDD VSS / NOR2X1
Xg707__4733 n_32 n_41 n_44 VDD VSS / OR2X1
Xg708__6161 n_28 n_36 n_43 VDD VSS / XNOR2X1
Xg709__9315 n_40 n_34 n_42 VDD VSS / AND2X1
Xg710__9945 n_39 n_35 n_41 VDD VSS / NOR2X1
Xg711__2883 n_31 inp_3 n_40 VDD VSS / NAND2X1
Xg712__2346 n_26 n_30 n_39 VDD VSS / AND2X1
Xg713__1666 n_31 n_33 n_38 VDD VSS / NAND2X1
Xg714__7410 n_24 n_29 inp_3 n_37 VDD VSS / MX2X1
Xg715__6417 n_22 n_26 n_36 VDD VSS / CLKXOR2X1
Xg716__5477 n_28 n_22 n_35 VDD VSS / NOR2X1
Xg717__2398 n_0 n_29 n_34 VDD VSS / OR2X1
Xg718 n_32 n_33 VDD VSS / CLKINVX1
Xg719__5107 n_22 n_28 n_30 VDD VSS / NAND2X1
Xg720__6260 n_27 n_23 n_32 VDD VSS / NOR2X1
Xg721__4319 n_27 n_23 n_31 VDD VSS / NAND2X1
Xg722__8428 n_24 err_2 n_29 VDD VSS / NAND2X1
Xg723__5526 n_25 err_1 n_28 VDD VSS / NAND2X1
Xg724__6783 n_3 n_18 n_27 VDD VSS / XNOR2X1
Xg725__3680 n_1 n_2 n_17 n_26 VDD VSS / MX2X1
Xg726__1617 n_21 inp_1 n_25 VDD VSS / AND2X1
Xg727__2802 n_20 n_12 n_24 VDD VSS / NOR2X1
Xg728__1705 n_19 n_14 n_23 VDD VSS / NAND2X1
Xg729__5122 n_16 n_8 n_21 VDD VSS / NOR2X1
Xg730__8246 n_13 n_2 n_20 VDD VSS / NOR2X1
Xg731__7098 n_15 err_0 n_22 VDD VSS / NAND2X1
Xg732__6131 n_11 n_2 n_19 VDD VSS / NAND2X1
Xg733__1881 n_1 n_2 n_6 n_18 VDD VSS / MX2X1
Xg734__5115 n_5 n_9 n_17 VDD VSS / CLKXOR2X1
Xg735__7482 n_7 inp_0 n_16 VDD VSS / NOR2X1
Xg736__4733 n_4 inp_0 n_15 VDD VSS / AND2X1
Xg737__6161 n_5 n_10 n_14 VDD VSS / NAND2X1
Xg738__9315 n_4 n_6 n_13 VDD VSS / NOR2X1
Xg739__9945 n_4 n_6 n_12 VDD VSS / AND2X1
Xg740__2883 n_10 n_5 n_11 VDD VSS / OR2X1
Xg741 n_9 n_10 VDD VSS / CLKINVX1
Xg742__2346 err_2 err_0 n_8 VDD VSS / NOR2X1
Xg743__1666 err_0 inp_2 n_7 VDD VSS / AND2X1
Xg744__7410 inp_2 err_1 n_9 VDD VSS / NAND2X1
Xg745 n_3 n_4 VDD VSS / CLKINVX1
Xg746 n_2 n_1 VDD VSS / CLKINVX1
Xg747__6417 err_1 inp_3 n_6 VDD VSS / NAND2X1
Xg748__5477 err_0 inp_3 n_5 VDD VSS / NAND2X1
Xg749__2398 err_2 inp_2 n_3 VDD VSS / NAND2X1
Xg750__5107 err_2 inp_1 n_2 VDD VSS / NAND2X1
Xg751 inp_3 n_0 VDD VSS / CLKINVX1
.ENDS dw4_77

*******************************************************************************
* MODULE: dw4_78
*******************************************************************************
.SUBCKT dw4_78 clk res err_0 err_1 err_2 err_3 inp_0 inp_1 inp_2 inp_3 dw_0 dw_1 dw_2 dw_3 VDD VSS
Xdw_reg_2 clk n_51 dw_2 VDD VSS / DFFQX1
Xg697__6260 res n_50 n_51 VDD VSS / NOR2X1
Xdw_reg_1 clk n_49 dw_1 VDD VSS / DFFQX1
Xg699__4319 n_37 n_46 n_50 VDD VSS / XNOR2X1
Xdw_reg_0 clk n_48 dw_0 VDD VSS / DFFQX1
Xg701__8428 res n_47 n_49 VDD VSS / NOR2X1
Xdw_reg_3 clk n_45 dw_3 VDD VSS / DFFQX1
Xg703__5526 res n_43 n_48 VDD VSS / NOR2X1
Xg704__6783 n_41 n_38 n_47 VDD VSS / XNOR2X1
Xg705__3680 n_44 n_31 n_46 VDD VSS / NAND2X1
Xg706__1617 res n_42 n_45 VDD VSS / NOR2X1
Xg707__2802 n_32 n_41 n_44 VDD VSS / OR2X1
Xg708__1705 n_28 n_36 n_43 VDD VSS / XNOR2X1
Xg709__5122 n_40 n_34 n_42 VDD VSS / AND2X1
Xg710__8246 n_39 n_35 n_41 VDD VSS / NOR2X1
Xg711__7098 n_31 inp_3 n_40 VDD VSS / NAND2X1
Xg712__6131 n_26 n_30 n_39 VDD VSS / AND2X1
Xg713__1881 n_31 n_33 n_38 VDD VSS / NAND2X1
Xg714__5115 n_24 n_29 inp_3 n_37 VDD VSS / MX2X1
Xg715__7482 n_22 n_26 n_36 VDD VSS / CLKXOR2X1
Xg716__4733 n_28 n_22 n_35 VDD VSS / NOR2X1
Xg717__6161 n_0 n_29 n_34 VDD VSS / OR2X1
Xg718 n_32 n_33 VDD VSS / CLKINVX1
Xg719__9315 n_22 n_28 n_30 VDD VSS / NAND2X1
Xg720__9945 n_27 n_23 n_32 VDD VSS / NOR2X1
Xg721__2883 n_27 n_23 n_31 VDD VSS / NAND2X1
Xg722__2346 n_24 err_2 n_29 VDD VSS / NAND2X1
Xg723__1666 n_25 err_1 n_28 VDD VSS / NAND2X1
Xg724__7410 n_3 n_18 n_27 VDD VSS / XNOR2X1
Xg725__6417 n_1 n_2 n_17 n_26 VDD VSS / MX2X1
Xg726__5477 n_21 inp_1 n_25 VDD VSS / AND2X1
Xg727__2398 n_20 n_12 n_24 VDD VSS / NOR2X1
Xg728__5107 n_19 n_14 n_23 VDD VSS / NAND2X1
Xg729__6260 n_16 n_8 n_21 VDD VSS / NOR2X1
Xg730__4319 n_13 n_2 n_20 VDD VSS / NOR2X1
Xg731__8428 n_15 err_0 n_22 VDD VSS / NAND2X1
Xg732__5526 n_11 n_2 n_19 VDD VSS / NAND2X1
Xg733__6783 n_1 n_2 n_6 n_18 VDD VSS / MX2X1
Xg734__3680 n_5 n_9 n_17 VDD VSS / CLKXOR2X1
Xg735__1617 n_7 inp_0 n_16 VDD VSS / NOR2X1
Xg736__2802 n_4 inp_0 n_15 VDD VSS / AND2X1
Xg737__1705 n_5 n_10 n_14 VDD VSS / NAND2X1
Xg738__5122 n_4 n_6 n_13 VDD VSS / NOR2X1
Xg739__8246 n_4 n_6 n_12 VDD VSS / AND2X1
Xg740__7098 n_10 n_5 n_11 VDD VSS / OR2X1
Xg741 n_9 n_10 VDD VSS / CLKINVX1
Xg742__6131 err_2 err_0 n_8 VDD VSS / NOR2X1
Xg743__1881 err_0 inp_2 n_7 VDD VSS / AND2X1
Xg744__5115 inp_2 err_1 n_9 VDD VSS / NAND2X1
Xg745 n_3 n_4 VDD VSS / CLKINVX1
Xg746 n_2 n_1 VDD VSS / CLKINVX1
Xg747__7482 err_1 inp_3 n_6 VDD VSS / NAND2X1
Xg748__4733 err_0 inp_3 n_5 VDD VSS / NAND2X1
Xg749__6161 err_2 inp_2 n_3 VDD VSS / NAND2X1
Xg750__9315 err_2 inp_1 n_2 VDD VSS / NAND2X1
Xg751 inp_3 n_0 VDD VSS / CLKINVX1
.ENDS dw4_78

*******************************************************************************
* MODULE: dw4_79
*******************************************************************************
.SUBCKT dw4_79 clk res err_0 err_1 err_2 err_3 inp_0 inp_1 inp_2 inp_3 dw_0 dw_1 dw_2 dw_3 VDD VSS
Xdw_reg_2 clk n_51 dw_2 VDD VSS / DFFQX1
Xg697__9315 res n_50 n_51 VDD VSS / NOR2X1
Xdw_reg_1 clk n_49 dw_1 VDD VSS / DFFQX1
Xg699__9945 n_37 n_46 n_50 VDD VSS / XNOR2X1
Xdw_reg_0 clk n_48 dw_0 VDD VSS / DFFQX1
Xg701__2883 res n_47 n_49 VDD VSS / NOR2X1
Xdw_reg_3 clk n_45 dw_3 VDD VSS / DFFQX1
Xg703__2346 res n_43 n_48 VDD VSS / NOR2X1
Xg704__1666 n_41 n_38 n_47 VDD VSS / XNOR2X1
Xg705__7410 n_44 n_31 n_46 VDD VSS / NAND2X1
Xg706__6417 res n_42 n_45 VDD VSS / NOR2X1
Xg707__5477 n_32 n_41 n_44 VDD VSS / OR2X1
Xg708__2398 n_28 n_36 n_43 VDD VSS / XNOR2X1
Xg709__5107 n_40 n_34 n_42 VDD VSS / AND2X1
Xg710__6260 n_39 n_35 n_41 VDD VSS / NOR2X1
Xg711__4319 n_31 inp_3 n_40 VDD VSS / NAND2X1
Xg712__8428 n_26 n_30 n_39 VDD VSS / AND2X1
Xg713__5526 n_31 n_33 n_38 VDD VSS / NAND2X1
Xg714__6783 n_24 n_29 inp_3 n_37 VDD VSS / MX2X1
Xg715__3680 n_22 n_26 n_36 VDD VSS / CLKXOR2X1
Xg716__1617 n_28 n_22 n_35 VDD VSS / NOR2X1
Xg717__2802 n_0 n_29 n_34 VDD VSS / OR2X1
Xg718 n_32 n_33 VDD VSS / CLKINVX1
Xg719__1705 n_22 n_28 n_30 VDD VSS / NAND2X1
Xg720__5122 n_27 n_23 n_32 VDD VSS / NOR2X1
Xg721__8246 n_27 n_23 n_31 VDD VSS / NAND2X1
Xg722__7098 n_24 err_2 n_29 VDD VSS / NAND2X1
Xg723__6131 n_25 err_1 n_28 VDD VSS / NAND2X1
Xg724__1881 n_3 n_18 n_27 VDD VSS / XNOR2X1
Xg725__5115 n_1 n_2 n_17 n_26 VDD VSS / MX2X1
Xg726__7482 n_21 inp_1 n_25 VDD VSS / AND2X1
Xg727__4733 n_20 n_12 n_24 VDD VSS / NOR2X1
Xg728__6161 n_19 n_14 n_23 VDD VSS / NAND2X1
Xg729__9315 n_16 n_8 n_21 VDD VSS / NOR2X1
Xg730__9945 n_13 n_2 n_20 VDD VSS / NOR2X1
Xg731__2883 n_15 err_0 n_22 VDD VSS / NAND2X1
Xg732__2346 n_11 n_2 n_19 VDD VSS / NAND2X1
Xg733__1666 n_1 n_2 n_6 n_18 VDD VSS / MX2X1
Xg734__7410 n_5 n_9 n_17 VDD VSS / CLKXOR2X1
Xg735__6417 n_7 inp_0 n_16 VDD VSS / NOR2X1
Xg736__5477 n_4 inp_0 n_15 VDD VSS / AND2X1
Xg737__2398 n_5 n_10 n_14 VDD VSS / NAND2X1
Xg738__5107 n_4 n_6 n_13 VDD VSS / NOR2X1
Xg739__6260 n_4 n_6 n_12 VDD VSS / AND2X1
Xg740__4319 n_10 n_5 n_11 VDD VSS / OR2X1
Xg741 n_9 n_10 VDD VSS / CLKINVX1
Xg742__8428 err_2 err_0 n_8 VDD VSS / NOR2X1
Xg743__5526 err_0 inp_2 n_7 VDD VSS / AND2X1
Xg744__6783 inp_2 err_1 n_9 VDD VSS / NAND2X1
Xg745 n_3 n_4 VDD VSS / CLKINVX1
Xg746 n_2 n_1 VDD VSS / CLKINVX1
Xg747__3680 err_1 inp_3 n_6 VDD VSS / NAND2X1
Xg748__1617 err_0 inp_3 n_5 VDD VSS / NAND2X1
Xg749__2802 err_2 inp_2 n_3 VDD VSS / NAND2X1
Xg750__1705 err_2 inp_1 n_2 VDD VSS / NAND2X1
Xg751 inp_3 n_0 VDD VSS / CLKINVX1
.ENDS dw4_79

*******************************************************************************
* MODULE: dw4_80
*******************************************************************************
.SUBCKT dw4_80 clk res err_0 err_1 err_2 err_3 inp_0 inp_1 inp_2 inp_3 dw_0 dw_1 dw_2 dw_3 VDD VSS
Xdw_reg_3 clk n_69 dw_3 VDD VSS / DFFQX1
Xg733__5107 res n_68 n_69 VDD VSS / NOR2X1
Xdw_reg_2 clk n_67 dw_2 VDD VSS / DFFQX1
Xg735__6260 n_45 n_65 n_68 VDD VSS / CLKXOR2X1
Xg736__4319 res n_66 n_67 VDD VSS / NOR2X1
Xdw_reg_1 clk n_64 dw_1 VDD VSS / DFFQX1
Xg738__8428 n_52 n_61 n_66 VDD VSS / XNOR2X1
Xg739__5526 n_63 n_48 n_65 VDD VSS / NAND2X1
Xdw_reg_0 clk n_62 dw_0 VDD VSS / DFFQX1
Xg741__6783 res n_60 n_64 VDD VSS / NOR2X1
Xg742__3680 n_61 n_47 n_63 VDD VSS / NAND2X1
Xg743__1617 res n_58 n_62 VDD VSS / NOR2X1
Xg744__2802 n_57 n_56 n_60 VDD VSS / XNOR2X1
Xg745__1705 n_59 n_0 n_61 VDD VSS / NAND2X1
Xg746__5122 n_57 n_53 n_59 VDD VSS / NAND2X1
Xg747__8246 n_43 n_54 n_58 VDD VSS / XNOR2X1
Xg748__7098 n_55 n_49 n_57 VDD VSS / NAND2X1
Xg749__6131 n_53 n_0 n_56 VDD VSS / AND2X1
Xg750__1881 n_43 n_50 n_55 VDD VSS / OR2X1
Xg751__5115 n_51 n_49 n_54 VDD VSS / NAND2X1
Xg752__7482 n_46 n_42 n_53 VDD VSS / NAND2X1
Xg753__4733 n_47 n_48 n_52 VDD VSS / AND2X1
Xg755 n_50 n_51 VDD VSS / CLKINVX1
Xg756__6161 n_40 n_26 n_50 VDD VSS / NOR2X1
Xg757__9315 n_40 n_26 n_49 VDD VSS / NAND2X1
Xg758__9945 n_44 n_41 n_48 VDD VSS / NAND2X1
Xg760__2883 n_41 n_44 n_47 VDD VSS / OR2X1
Xg761__2346 n_1 n_36 n_45 VDD VSS / XNOR2X1
Xg762__1666 n_30 n_35 n_46 VDD VSS / CLKXOR2X1
Xg763__7410 n_39 n_32 n_44 VDD VSS / NAND2X1
Xg764__6417 n_38 inp_1 n_43 VDD VSS / NAND2X1
Xg766__5477 n_37 n_19 n_42 VDD VSS / NOR2X1
Xg767__2398 n_22 n_27 n_41 VDD VSS / CLKXOR2X1
Xg768__5107 n_28 n_29 n_40 VDD VSS / CLKXOR2X1
Xg769__6260 n_31 n_30 n_39 VDD VSS / NAND2X1
Xg770__4319 n_33 err_1 n_38 VDD VSS / AND2X1
Xg771__8428 n_29 n_21 n_37 VDD VSS / AND2X1
Xg772__5526 n_34 n_20 n_36 VDD VSS / NOR2X1
Xg773__6783 n_3 n_25 n_35 VDD VSS / XNOR2X1
Xg774__3680 n_22 n_24 n_34 VDD VSS / NOR2X1
Xg775__1617 n_23 n_15 n_33 VDD VSS / NAND2X1
Xg776__2802 n_25 n_3 n_32 VDD VSS / NAND2X1
Xg777__1705 n_3 n_25 n_31 VDD VSS / OR2X1
Xg778__5122 n_9 n_4 n_28 VDD VSS / XNOR2X1
Xg779__8246 n_5 n_11 n_27 VDD VSS / XNOR2X1
Xg780__7098 n_18 n_22 n_30 VDD VSS / OR2X1
Xg781__6131 n_12 n_13 n_29 VDD VSS / XNOR2X1
Xg782__1881 n_11 n_5 n_24 VDD VSS / NOR2X1
Xg783__5115 n_6 n_2 n_23 VDD VSS / AND2X1
Xg784__7482 n_6 n_15 n_26 VDD VSS / NOR2X1
Xg785__4733 n_12 n_14 n_25 VDD VSS / NOR2X1
Xg786__6161 n_10 n_4 n_21 VDD VSS / NAND2X1
Xg787__9315 n_11 n_5 n_20 VDD VSS / AND2X1
Xg788__9945 n_4 n_10 n_19 VDD VSS / NOR2X1
Xg789__2883 n_8 n_16 n_18 VDD VSS / NOR2X1
Xg790__2346 n_17 n_7 n_22 VDD VSS / NOR2X1
Xg791 n_16 n_17 VDD VSS / CLKINVX1
Xg792 n_13 n_14 VDD VSS / CLKINVX1
Xg793 n_9 n_10 VDD VSS / CLKINVX1
Xg794__1666 err_2 inp_2 n_16 VDD VSS / NAND2X1
Xg795__7410 err_0 inp_2 n_15 VDD VSS / NAND2X1
Xg796__6417 err_3 inp_0 n_13 VDD VSS / NAND2X1
Xg797__5477 err_2 inp_1 n_12 VDD VSS / NAND2X1
Xg798__2398 err_3 inp_2 n_11 VDD VSS / NAND2X1
Xg799__5107 err_0 inp_3 n_9 VDD VSS / NAND2X1
Xg800 n_7 n_8 VDD VSS / CLKINVX1
Xg801__6260 err_0 inp_0 n_2 VDD VSS / NAND2X1
Xg802__4319 err_3 inp_3 n_1 VDD VSS / NAND2X1
Xg803__8428 err_3 inp_1 n_7 VDD VSS / NAND2X1
Xg804__5526 err_2 inp_0 n_6 VDD VSS / NAND2X1
Xg805__6783 err_2 inp_3 n_5 VDD VSS / NAND2X1
Xg806__3680 err_1 inp_2 n_4 VDD VSS / NAND2X1
Xg807__1617 err_1 inp_3 n_3 VDD VSS / NAND2X1
Xg2__2802 n_46 n_42 n_0 VDD VSS / OR2X1
.ENDS dw4_80

*******************************************************************************
* MODULE: dw_adder4
*******************************************************************************
.SUBCKT dw_adder4 clk res dw_0 dw_1 dw_2 dw_3 cap_dw_0 cap_dw_1 cap_dw_2 cap_dw_3 VDD VSS
Xcap_dw_reg_0 clk n_92 cap_dw_0 VDD VSS / DFFQX1
Xg959 res n_91 n_92 VDD VSS / NOR2X1
Xcap_dw_reg_1 clk n_89 cap_dw_3 VDD VSS / DFFQX1
Xg961 n_90 n_88 n_91 VDD VSS / NOR2X1
Xg962 n_87 n_85 n_90 VDD VSS / NAND2X1
Xg963 n_1 n_88 n_89 VDD VSS / AND2X1
Xg964 n_86 n_74 n_88 VDD VSS / NOR2X1
Xg965 n_84 n_81 n_87 VDD VSS / NOR2X1
Xg966 n_83 n_73 n_86 VDD VSS / AND2X1
Xg967 n_83 n_74 n_85 VDD VSS / NAND2X1
Xg968 n_82 n_51 n_84 VDD VSS / NAND2X1
Xg969 n_80 n_62 n_83 VDD VSS / NAND2X1
Xg970 n_79 n_77 n_82 VDD VSS / NOR2X1
Xg971 n_78 n_60 n_81 VDD VSS / NOR2X1
Xg972 n_76 n_61 n_80 VDD VSS / NAND2X1
Xg973 n_75 n_60 n_79 VDD VSS / AND2X1
Xg974 n_71 n_64 n_78 VDD VSS / NOR2X1
Xg975 n_69 n_68 n_77 VDD VSS / NAND2X1
Xg976 n_72 n_65 n_76 VDD VSS / NAND2X1
Xg977 n_70 n_71 n_75 VDD VSS / NAND2X1
Xg978 n_67 n_35 n_73 VDD VSS / NAND2X1
Xg979 n_64 n_60 n_72 VDD VSS / NAND2X1
Xg980 n_67 n_35 n_74 VDD VSS / NOR2X1
Xg981 n_63 n_65 n_70 VDD VSS / NAND2X1
Xg982 n_64 n_66 n_69 VDD VSS / NAND2X1
Xg983 n_43 n_57 n_68 VDD VSS / CLKXOR2X1
Xg984 n_61 n_62 n_71 VDD VSS / AND2X1
Xg985 n_65 n_66 VDD VSS / CLKINVX1
Xg986 n_64 n_63 VDD VSS / CLKINVX1
Xg987 n_58 n_47 n_67 VDD VSS / NOR2X1
Xg988 n_56 n_45 n_65 VDD VSS / NAND2X1
Xg989 n_59 n_50 n_64 VDD VSS / NAND2X1
Xg990 n_53 n_54 n_62 VDD VSS / NAND2X1
Xg991 n_52 n_55 n_61 VDD VSS / NAND2X1
Xg992 n_45 n_56 n_60 VDD VSS / OR2X1
Xg993 n_48 n_43 n_59 VDD VSS / NAND2X1
Xg994 n_49 n_34 n_58 VDD VSS / AND2X1
Xg995 n_48 n_50 n_57 VDD VSS / NAND2X1
Xg996 n_54 n_55 VDD VSS / CLKINVX1
Xg997 n_52 n_53 VDD VSS / CLKINVX1
Xg998 dw_0 n_40 n_51 VDD VSS / CLKXOR2X1
Xg999 n_36 n_42 n_56 VDD VSS / XNOR2X1
Xg1000 n_46 n_32 n_54 VDD VSS / NAND2X1
Xg1001 n_41 n_39 n_52 VDD VSS / CLKXOR2X1
Xg1002 n_41 dw_3 n_49 VDD VSS / NAND2X1
Xg1003 n_25 n_44 n_50 VDD VSS / OR2X1
Xg1004 n_41 dw_3 n_47 VDD VSS / NOR2X1
Xg1005 n_42 n_33 n_46 VDD VSS / NAND2X1
Xg1006 n_44 n_25 n_48 VDD VSS / NAND2X1
Xg1007 n_38 n_14 n_45 VDD VSS / NAND2X1
Xg1008 n_23 n_31 n_44 VDD VSS / CLKXOR2X1
Xg1009 n_37 n_8 n_43 VDD VSS / NAND2X1
Xg1010 d1_0 n_30 n_40 VDD VSS / XNOR2X1
Xg1011 dw_3 n_34 n_39 VDD VSS / XNOR2X1
Xg1012 d2_2 n_28 n_42 VDD VSS / XNOR2X1
Xg1013 d2_3 n_29 n_41 VDD VSS / XNOR2X1
Xg1014 n_31 n_17 n_38 VDD VSS / NAND2X1
Xg1015 n_30 n_7 n_37 VDD VSS / NAND2X1
Xg1016 dw_2 n_24 n_36 VDD VSS / CLKXOR2X1
Xg1017 n_24 n_2 n_33 VDD VSS / NAND2X1
Xg1018 n_2 n_24 n_32 VDD VSS / OR2X1
Xg1019 n_26 n_18 n_35 VDD VSS / NOR2X1
Xg1020 n_27 n_16 n_34 VDD VSS / NAND2X1
Xg1021 d1_3 d3_3 n_29 VDD VSS / XNOR2X1
Xg1022 d1_2 d3_2 n_28 VDD VSS / XNOR2X1
Xg1023 d1_1 d3_1 n_31 VDD VSS / CLKXOR2X1
Xg1024 d2_0 d3_0 n_30 VDD VSS / CLKXOR2X1
Xg1025 n_13 d3_2 n_27 VDD VSS / NAND2X1
Xg1026 n_15 d3_3 n_26 VDD VSS / NOR2X1
Xg1027 d3_0 d2_0 n_25 VDD VSS / NAND2X1
Xg1028 d3_1 d1_1 n_24 VDD VSS / NAND2X1
Xd3_reg_0 clk n_20 d3_0 VDD VSS / DFFQX1
Xd3_reg_2 clk n_19 d3_2 VDD VSS / DFFQX1
Xg1031 dw_1 d2_1 n_23 VDD VSS / XNOR2X1
Xd3_reg_1 clk n_21 d3_1 VDD VSS / DFFQX1
Xd3_reg_3 clk n_22 d3_3 VDD VSS / DFFQX1
Xg1034 n_1 d2_3 n_22 VDD VSS / AND2X1
Xg1035 n_1 d2_1 n_21 VDD VSS / AND2X1
Xg1036 n_1 d2_0 n_20 VDD VSS / AND2X1
Xg1037 n_1 d2_2 n_19 VDD VSS / AND2X1
Xg1038 d2_3 d1_3 n_18 VDD VSS / NOR2X1
Xg1039 dw_1 d2_1 n_17 VDD VSS / OR2X1
Xg1040 d2_2 d1_2 n_16 VDD VSS / NAND2X1
Xg1041 d1_3 d2_3 n_15 VDD VSS / AND2X1
Xg1042 d2_1 dw_1 n_14 VDD VSS / NAND2X1
Xg1043 d1_2 d2_2 n_13 VDD VSS / OR2X1
Xd2_reg_1 clk n_12 d2_1 VDD VSS / DFFQX1
Xd2_reg_2 clk n_9 d2_2 VDD VSS / DFFQX1
Xd2_reg_0 clk n_10 d2_0 VDD VSS / DFFQX1
Xd2_reg_3 clk n_11 d2_3 VDD VSS / DFFQX1
Xg1048 n_1 d1_1 n_12 VDD VSS / AND2X1
Xg1049 n_1 d1_3 n_11 VDD VSS / AND2X1
Xg1050 n_1 d1_0 n_10 VDD VSS / AND2X1
Xg1051 n_1 d1_2 n_9 VDD VSS / AND2X1
Xg1052 d1_0 dw_0 n_8 VDD VSS / NAND2X1
Xg1053 dw_0 d1_0 n_7 VDD VSS / OR2X1
Xd1_reg_1 clk n_4 d1_1 VDD VSS / DFFQX1
Xd1_reg_2 clk n_6 d1_2 VDD VSS / DFFQX1
Xd1_reg_3 clk n_5 d1_3 VDD VSS / DFFQX1
Xd1_reg_0 clk n_3 d1_0 VDD VSS / DFFQX1
Xg1058 res n_2 n_6 VDD VSS / NOR2X1
Xg1059 n_1 dw_3 n_5 VDD VSS / AND2X1
Xg1060 n_1 dw_1 n_4 VDD VSS / AND2X1
Xg1061 n_1 dw_0 n_3 VDD VSS / AND2X1
Xg1062 dw_2 n_2 VDD VSS / CLKINVX1
Xg1063 res n_1 VDD VSS / CLKINVX1
.ENDS dw_adder4

*******************************************************************************
* MODULE: dw_adder4_81
*******************************************************************************
.SUBCKT dw_adder4_81 clk res dw_0 dw_1 dw_2 dw_3 cap_dw_0 cap_dw_1 cap_dw_2 cap_dw_3 VDD VSS
Xcap_dw_reg_0 clk n_92 cap_dw_0 VDD VSS / DFFQX1
Xg959 res n_91 n_92 VDD VSS / NOR2X1
Xcap_dw_reg_1 clk n_89 cap_dw_3 VDD VSS / DFFQX1
Xg961 n_90 n_88 n_91 VDD VSS / NOR2X1
Xg962 n_87 n_85 n_90 VDD VSS / NAND2X1
Xg963 n_1 n_88 n_89 VDD VSS / AND2X1
Xg964 n_86 n_74 n_88 VDD VSS / NOR2X1
Xg965 n_84 n_81 n_87 VDD VSS / NOR2X1
Xg966 n_83 n_73 n_86 VDD VSS / AND2X1
Xg967 n_83 n_74 n_85 VDD VSS / NAND2X1
Xg968 n_82 n_51 n_84 VDD VSS / NAND2X1
Xg969 n_80 n_62 n_83 VDD VSS / NAND2X1
Xg970 n_79 n_77 n_82 VDD VSS / NOR2X1
Xg971 n_78 n_60 n_81 VDD VSS / NOR2X1
Xg972 n_76 n_61 n_80 VDD VSS / NAND2X1
Xg973 n_75 n_60 n_79 VDD VSS / AND2X1
Xg974 n_71 n_64 n_78 VDD VSS / NOR2X1
Xg975 n_69 n_68 n_77 VDD VSS / NAND2X1
Xg976 n_72 n_65 n_76 VDD VSS / NAND2X1
Xg977 n_70 n_71 n_75 VDD VSS / NAND2X1
Xg978 n_67 n_35 n_73 VDD VSS / NAND2X1
Xg979 n_64 n_60 n_72 VDD VSS / NAND2X1
Xg980 n_67 n_35 n_74 VDD VSS / NOR2X1
Xg981 n_63 n_65 n_70 VDD VSS / NAND2X1
Xg982 n_64 n_66 n_69 VDD VSS / NAND2X1
Xg983 n_43 n_57 n_68 VDD VSS / CLKXOR2X1
Xg984 n_61 n_62 n_71 VDD VSS / AND2X1
Xg985 n_65 n_66 VDD VSS / CLKINVX1
Xg986 n_64 n_63 VDD VSS / CLKINVX1
Xg987 n_58 n_47 n_67 VDD VSS / NOR2X1
Xg988 n_56 n_45 n_65 VDD VSS / NAND2X1
Xg989 n_59 n_50 n_64 VDD VSS / NAND2X1
Xg990 n_53 n_54 n_62 VDD VSS / NAND2X1
Xg991 n_52 n_55 n_61 VDD VSS / NAND2X1
Xg992 n_45 n_56 n_60 VDD VSS / OR2X1
Xg993 n_48 n_43 n_59 VDD VSS / NAND2X1
Xg994 n_49 n_34 n_58 VDD VSS / AND2X1
Xg995 n_48 n_50 n_57 VDD VSS / NAND2X1
Xg996 n_54 n_55 VDD VSS / CLKINVX1
Xg997 n_52 n_53 VDD VSS / CLKINVX1
Xg998 dw_0 n_40 n_51 VDD VSS / CLKXOR2X1
Xg999 n_36 n_42 n_56 VDD VSS / XNOR2X1
Xg1000 n_46 n_32 n_54 VDD VSS / NAND2X1
Xg1001 n_41 n_39 n_52 VDD VSS / CLKXOR2X1
Xg1002 n_41 dw_3 n_49 VDD VSS / NAND2X1
Xg1003 n_25 n_44 n_50 VDD VSS / OR2X1
Xg1004 n_41 dw_3 n_47 VDD VSS / NOR2X1
Xg1005 n_42 n_33 n_46 VDD VSS / NAND2X1
Xg1006 n_44 n_25 n_48 VDD VSS / NAND2X1
Xg1007 n_38 n_14 n_45 VDD VSS / NAND2X1
Xg1008 n_23 n_31 n_44 VDD VSS / CLKXOR2X1
Xg1009 n_37 n_8 n_43 VDD VSS / NAND2X1
Xg1010 d1_0 n_30 n_40 VDD VSS / XNOR2X1
Xg1011 dw_3 n_34 n_39 VDD VSS / XNOR2X1
Xg1012 d2_2 n_28 n_42 VDD VSS / XNOR2X1
Xg1013 d2_3 n_29 n_41 VDD VSS / XNOR2X1
Xg1014 n_31 n_17 n_38 VDD VSS / NAND2X1
Xg1015 n_30 n_7 n_37 VDD VSS / NAND2X1
Xg1016 dw_2 n_24 n_36 VDD VSS / CLKXOR2X1
Xg1017 n_24 n_2 n_33 VDD VSS / NAND2X1
Xg1018 n_2 n_24 n_32 VDD VSS / OR2X1
Xg1019 n_26 n_18 n_35 VDD VSS / NOR2X1
Xg1020 n_27 n_16 n_34 VDD VSS / NAND2X1
Xg1021 d1_3 d3_3 n_29 VDD VSS / XNOR2X1
Xg1022 d1_2 d3_2 n_28 VDD VSS / XNOR2X1
Xg1023 d1_1 d3_1 n_31 VDD VSS / CLKXOR2X1
Xg1024 d2_0 d3_0 n_30 VDD VSS / CLKXOR2X1
Xg1025 n_13 d3_2 n_27 VDD VSS / NAND2X1
Xg1026 n_15 d3_3 n_26 VDD VSS / NOR2X1
Xg1027 d3_0 d2_0 n_25 VDD VSS / NAND2X1
Xg1028 d3_1 d1_1 n_24 VDD VSS / NAND2X1
Xd3_reg_0 clk n_20 d3_0 VDD VSS / DFFQX1
Xd3_reg_2 clk n_19 d3_2 VDD VSS / DFFQX1
Xg1031 dw_1 d2_1 n_23 VDD VSS / XNOR2X1
Xd3_reg_1 clk n_21 d3_1 VDD VSS / DFFQX1
Xd3_reg_3 clk n_22 d3_3 VDD VSS / DFFQX1
Xg1034 n_1 d2_3 n_22 VDD VSS / AND2X1
Xg1035 n_1 d2_1 n_21 VDD VSS / AND2X1
Xg1036 n_1 d2_0 n_20 VDD VSS / AND2X1
Xg1037 n_1 d2_2 n_19 VDD VSS / AND2X1
Xg1038 d2_3 d1_3 n_18 VDD VSS / NOR2X1
Xg1039 dw_1 d2_1 n_17 VDD VSS / OR2X1
Xg1040 d2_2 d1_2 n_16 VDD VSS / NAND2X1
Xg1041 d1_3 d2_3 n_15 VDD VSS / AND2X1
Xg1042 d2_1 dw_1 n_14 VDD VSS / NAND2X1
Xg1043 d1_2 d2_2 n_13 VDD VSS / OR2X1
Xd2_reg_1 clk n_12 d2_1 VDD VSS / DFFQX1
Xd2_reg_2 clk n_9 d2_2 VDD VSS / DFFQX1
Xd2_reg_0 clk n_10 d2_0 VDD VSS / DFFQX1
Xd2_reg_3 clk n_11 d2_3 VDD VSS / DFFQX1
Xg1048 n_1 d1_1 n_12 VDD VSS / AND2X1
Xg1049 n_1 d1_3 n_11 VDD VSS / AND2X1
Xg1050 n_1 d1_0 n_10 VDD VSS / AND2X1
Xg1051 n_1 d1_2 n_9 VDD VSS / AND2X1
Xg1052 d1_0 dw_0 n_8 VDD VSS / NAND2X1
Xg1053 dw_0 d1_0 n_7 VDD VSS / OR2X1
Xd1_reg_1 clk n_4 d1_1 VDD VSS / DFFQX1
Xd1_reg_2 clk n_6 d1_2 VDD VSS / DFFQX1
Xd1_reg_3 clk n_5 d1_3 VDD VSS / DFFQX1
Xd1_reg_0 clk n_3 d1_0 VDD VSS / DFFQX1
Xg1058 res n_2 n_6 VDD VSS / NOR2X1
Xg1059 n_1 dw_3 n_5 VDD VSS / AND2X1
Xg1060 n_1 dw_1 n_4 VDD VSS / AND2X1
Xg1061 n_1 dw_0 n_3 VDD VSS / AND2X1
Xg1062 dw_2 n_2 VDD VSS / CLKINVX1
Xg1063 res n_1 VDD VSS / CLKINVX1
.ENDS dw_adder4_81

*******************************************************************************
* MODULE: dw_adder4_82
*******************************************************************************
.SUBCKT dw_adder4_82 clk res dw_0 dw_1 dw_2 dw_3 cap_dw_0 cap_dw_1 cap_dw_2 cap_dw_3 VDD VSS
Xcap_dw_reg_0 clk n_92 cap_dw_0 VDD VSS / DFFQX1
Xg959__9315 res n_91 n_92 VDD VSS / NOR2X1
Xcap_dw_reg_1 clk n_89 cap_dw_3 VDD VSS / DFFQX1
Xg961__9945 n_90 n_88 n_91 VDD VSS / NOR2X1
Xg962__2883 n_87 n_85 n_90 VDD VSS / NAND2X1
Xg963__2346 n_1 n_88 n_89 VDD VSS / AND2X1
Xg964__1666 n_86 n_74 n_88 VDD VSS / NOR2X1
Xg965__7410 n_84 n_81 n_87 VDD VSS / NOR2X1
Xg966__6417 n_83 n_73 n_86 VDD VSS / AND2X1
Xg967__5477 n_83 n_74 n_85 VDD VSS / NAND2X1
Xg968__2398 n_82 n_51 n_84 VDD VSS / NAND2X1
Xg969__5107 n_80 n_62 n_83 VDD VSS / NAND2X1
Xg970__6260 n_79 n_77 n_82 VDD VSS / NOR2X1
Xg971__4319 n_78 n_60 n_81 VDD VSS / NOR2X1
Xg972__8428 n_76 n_61 n_80 VDD VSS / NAND2X1
Xg973__5526 n_75 n_60 n_79 VDD VSS / AND2X1
Xg974__6783 n_71 n_64 n_78 VDD VSS / NOR2X1
Xg975__3680 n_69 n_68 n_77 VDD VSS / NAND2X1
Xg976__1617 n_72 n_65 n_76 VDD VSS / NAND2X1
Xg977__2802 n_70 n_71 n_75 VDD VSS / NAND2X1
Xg978__1705 n_67 n_35 n_73 VDD VSS / NAND2X1
Xg979__5122 n_64 n_60 n_72 VDD VSS / NAND2X1
Xg980__8246 n_67 n_35 n_74 VDD VSS / NOR2X1
Xg981__7098 n_63 n_65 n_70 VDD VSS / NAND2X1
Xg982__6131 n_64 n_66 n_69 VDD VSS / NAND2X1
Xg983__1881 n_43 n_57 n_68 VDD VSS / CLKXOR2X1
Xg984__5115 n_61 n_62 n_71 VDD VSS / AND2X1
Xg985 n_65 n_66 VDD VSS / CLKINVX1
Xg986 n_64 n_63 VDD VSS / CLKINVX1
Xg987__7482 n_58 n_47 n_67 VDD VSS / NOR2X1
Xg988__4733 n_56 n_45 n_65 VDD VSS / NAND2X1
Xg989__6161 n_59 n_50 n_64 VDD VSS / NAND2X1
Xg990__9315 n_53 n_54 n_62 VDD VSS / NAND2X1
Xg991__9945 n_52 n_55 n_61 VDD VSS / NAND2X1
Xg992__2883 n_45 n_56 n_60 VDD VSS / OR2X1
Xg993__2346 n_48 n_43 n_59 VDD VSS / NAND2X1
Xg994__1666 n_49 n_34 n_58 VDD VSS / AND2X1
Xg995__7410 n_48 n_50 n_57 VDD VSS / NAND2X1
Xg996 n_54 n_55 VDD VSS / CLKINVX1
Xg997 n_52 n_53 VDD VSS / CLKINVX1
Xg998__6417 dw_0 n_40 n_51 VDD VSS / CLKXOR2X1
Xg999__5477 n_36 n_42 n_56 VDD VSS / XNOR2X1
Xg1000__2398 n_46 n_32 n_54 VDD VSS / NAND2X1
Xg1001__5107 n_41 n_39 n_52 VDD VSS / CLKXOR2X1
Xg1002__6260 n_41 dw_3 n_49 VDD VSS / NAND2X1
Xg1003__4319 n_25 n_44 n_50 VDD VSS / OR2X1
Xg1004__8428 n_41 dw_3 n_47 VDD VSS / NOR2X1
Xg1005__5526 n_42 n_33 n_46 VDD VSS / NAND2X1
Xg1006__6783 n_44 n_25 n_48 VDD VSS / NAND2X1
Xg1007__3680 n_38 n_14 n_45 VDD VSS / NAND2X1
Xg1008__1617 n_23 n_31 n_44 VDD VSS / CLKXOR2X1
Xg1009__2802 n_37 n_8 n_43 VDD VSS / NAND2X1
Xg1010__1705 d1_0 n_30 n_40 VDD VSS / XNOR2X1
Xg1011__5122 dw_3 n_34 n_39 VDD VSS / XNOR2X1
Xg1012__8246 d2_2 n_28 n_42 VDD VSS / XNOR2X1
Xg1013__7098 d2_3 n_29 n_41 VDD VSS / XNOR2X1
Xg1014__6131 n_31 n_17 n_38 VDD VSS / NAND2X1
Xg1015__1881 n_30 n_7 n_37 VDD VSS / NAND2X1
Xg1016__5115 dw_2 n_24 n_36 VDD VSS / CLKXOR2X1
Xg1017__7482 n_24 n_2 n_33 VDD VSS / NAND2X1
Xg1018__4733 n_2 n_24 n_32 VDD VSS / OR2X1
Xg1019__6161 n_26 n_18 n_35 VDD VSS / NOR2X1
Xg1020__9315 n_27 n_16 n_34 VDD VSS / NAND2X1
Xg1021__9945 d1_3 d3_3 n_29 VDD VSS / XNOR2X1
Xg1022__2883 d1_2 d3_2 n_28 VDD VSS / XNOR2X1
Xg1023__2346 d1_1 d3_1 n_31 VDD VSS / CLKXOR2X1
Xg1024__1666 d2_0 d3_0 n_30 VDD VSS / CLKXOR2X1
Xg1025__7410 n_13 d3_2 n_27 VDD VSS / NAND2X1
Xg1026__6417 n_15 d3_3 n_26 VDD VSS / NOR2X1
Xg1027__5477 d3_0 d2_0 n_25 VDD VSS / NAND2X1
Xg1028__2398 d3_1 d1_1 n_24 VDD VSS / NAND2X1
Xd3_reg_0 clk n_20 d3_0 VDD VSS / DFFQX1
Xd3_reg_2 clk n_19 d3_2 VDD VSS / DFFQX1
Xg1031__5107 dw_1 d2_1 n_23 VDD VSS / XNOR2X1
Xd3_reg_1 clk n_21 d3_1 VDD VSS / DFFQX1
Xd3_reg_3 clk n_22 d3_3 VDD VSS / DFFQX1
Xg1034__6260 n_1 d2_3 n_22 VDD VSS / AND2X1
Xg1035__4319 n_1 d2_1 n_21 VDD VSS / AND2X1
Xg1036__8428 n_1 d2_0 n_20 VDD VSS / AND2X1
Xg1037__5526 n_1 d2_2 n_19 VDD VSS / AND2X1
Xg1038__6783 d2_3 d1_3 n_18 VDD VSS / NOR2X1
Xg1039__3680 dw_1 d2_1 n_17 VDD VSS / OR2X1
Xg1040__1617 d2_2 d1_2 n_16 VDD VSS / NAND2X1
Xg1041__2802 d1_3 d2_3 n_15 VDD VSS / AND2X1
Xg1042__1705 d2_1 dw_1 n_14 VDD VSS / NAND2X1
Xg1043__5122 d1_2 d2_2 n_13 VDD VSS / OR2X1
Xd2_reg_1 clk n_12 d2_1 VDD VSS / DFFQX1
Xd2_reg_2 clk n_9 d2_2 VDD VSS / DFFQX1
Xd2_reg_0 clk n_10 d2_0 VDD VSS / DFFQX1
Xd2_reg_3 clk n_11 d2_3 VDD VSS / DFFQX1
Xg1048__8246 n_1 d1_1 n_12 VDD VSS / AND2X1
Xg1049__7098 n_1 d1_3 n_11 VDD VSS / AND2X1
Xg1050__6131 n_1 d1_0 n_10 VDD VSS / AND2X1
Xg1051__1881 n_1 d1_2 n_9 VDD VSS / AND2X1
Xg1052__5115 d1_0 dw_0 n_8 VDD VSS / NAND2X1
Xg1053__7482 dw_0 d1_0 n_7 VDD VSS / OR2X1
Xd1_reg_1 clk n_4 d1_1 VDD VSS / DFFQX1
Xd1_reg_2 clk n_6 d1_2 VDD VSS / DFFQX1
Xd1_reg_3 clk n_5 d1_3 VDD VSS / DFFQX1
Xd1_reg_0 clk n_3 d1_0 VDD VSS / DFFQX1
Xg1058__4733 res n_2 n_6 VDD VSS / NOR2X1
Xg1059__6161 n_1 dw_3 n_5 VDD VSS / AND2X1
Xg1060__9315 n_1 dw_1 n_4 VDD VSS / AND2X1
Xg1061__9945 n_1 dw_0 n_3 VDD VSS / AND2X1
Xg1062 dw_2 n_2 VDD VSS / CLKINVX1
Xg1063 res n_1 VDD VSS / CLKINVX1
.ENDS dw_adder4_82

*******************************************************************************
* MODULE: dw_adder4_83
*******************************************************************************
.SUBCKT dw_adder4_83 clk res dw_0 dw_1 dw_2 dw_3 cap_dw_0 cap_dw_1 cap_dw_2 cap_dw_3 VDD VSS
Xcap_dw_reg_0 clk n_92 cap_dw_0 VDD VSS / DFFQX1
Xg959__2883 res n_91 n_92 VDD VSS / NOR2X1
Xcap_dw_reg_1 clk n_89 cap_dw_3 VDD VSS / DFFQX1
Xg961__2346 n_90 n_88 n_91 VDD VSS / NOR2X1
Xg962__1666 n_87 n_85 n_90 VDD VSS / NAND2X1
Xg963__7410 n_1 n_88 n_89 VDD VSS / AND2X1
Xg964__6417 n_86 n_74 n_88 VDD VSS / NOR2X1
Xg965__5477 n_84 n_81 n_87 VDD VSS / NOR2X1
Xg966__2398 n_83 n_73 n_86 VDD VSS / AND2X1
Xg967__5107 n_83 n_74 n_85 VDD VSS / NAND2X1
Xg968__6260 n_82 n_51 n_84 VDD VSS / NAND2X1
Xg969__4319 n_80 n_62 n_83 VDD VSS / NAND2X1
Xg970__8428 n_79 n_77 n_82 VDD VSS / NOR2X1
Xg971__5526 n_78 n_60 n_81 VDD VSS / NOR2X1
Xg972__6783 n_76 n_61 n_80 VDD VSS / NAND2X1
Xg973__3680 n_75 n_60 n_79 VDD VSS / AND2X1
Xg974__1617 n_71 n_64 n_78 VDD VSS / NOR2X1
Xg975__2802 n_69 n_68 n_77 VDD VSS / NAND2X1
Xg976__1705 n_72 n_65 n_76 VDD VSS / NAND2X1
Xg977__5122 n_70 n_71 n_75 VDD VSS / NAND2X1
Xg978__8246 n_67 n_35 n_73 VDD VSS / NAND2X1
Xg979__7098 n_64 n_60 n_72 VDD VSS / NAND2X1
Xg980__6131 n_67 n_35 n_74 VDD VSS / NOR2X1
Xg981__1881 n_63 n_65 n_70 VDD VSS / NAND2X1
Xg982__5115 n_64 n_66 n_69 VDD VSS / NAND2X1
Xg983__7482 n_43 n_57 n_68 VDD VSS / CLKXOR2X1
Xg984__4733 n_61 n_62 n_71 VDD VSS / AND2X1
Xg985 n_65 n_66 VDD VSS / CLKINVX1
Xg986 n_64 n_63 VDD VSS / CLKINVX1
Xg987__6161 n_58 n_47 n_67 VDD VSS / NOR2X1
Xg988 n_56 n_45 n_65 VDD VSS / NAND2X1
Xg989 n_59 n_50 n_64 VDD VSS / NAND2X1
Xg990 n_53 n_54 n_62 VDD VSS / NAND2X1
Xg991 n_52 n_55 n_61 VDD VSS / NAND2X1
Xg992 n_45 n_56 n_60 VDD VSS / OR2X1
Xg993 n_48 n_43 n_59 VDD VSS / NAND2X1
Xg994 n_49 n_34 n_58 VDD VSS / AND2X1
Xg995 n_48 n_50 n_57 VDD VSS / NAND2X1
Xg996 n_54 n_55 VDD VSS / CLKINVX1
Xg997 n_52 n_53 VDD VSS / CLKINVX1
Xg998 dw_0 n_40 n_51 VDD VSS / CLKXOR2X1
Xg999 n_36 n_42 n_56 VDD VSS / XNOR2X1
Xg1000 n_46 n_32 n_54 VDD VSS / NAND2X1
Xg1001 n_41 n_39 n_52 VDD VSS / CLKXOR2X1
Xg1002 n_41 dw_3 n_49 VDD VSS / NAND2X1
Xg1003 n_25 n_44 n_50 VDD VSS / OR2X1
Xg1004 n_41 dw_3 n_47 VDD VSS / NOR2X1
Xg1005 n_42 n_33 n_46 VDD VSS / NAND2X1
Xg1006 n_44 n_25 n_48 VDD VSS / NAND2X1
Xg1007 n_38 n_14 n_45 VDD VSS / NAND2X1
Xg1008 n_23 n_31 n_44 VDD VSS / CLKXOR2X1
Xg1009 n_37 n_8 n_43 VDD VSS / NAND2X1
Xg1010 d1_0 n_30 n_40 VDD VSS / XNOR2X1
Xg1011 dw_3 n_34 n_39 VDD VSS / XNOR2X1
Xg1012 d2_2 n_28 n_42 VDD VSS / XNOR2X1
Xg1013 d2_3 n_29 n_41 VDD VSS / XNOR2X1
Xg1014 n_31 n_17 n_38 VDD VSS / NAND2X1
Xg1015 n_30 n_7 n_37 VDD VSS / NAND2X1
Xg1016 dw_2 n_24 n_36 VDD VSS / CLKXOR2X1
Xg1017 n_24 n_2 n_33 VDD VSS / NAND2X1
Xg1018 n_2 n_24 n_32 VDD VSS / OR2X1
Xg1019 n_26 n_18 n_35 VDD VSS / NOR2X1
Xg1020 n_27 n_16 n_34 VDD VSS / NAND2X1
Xg1021 d1_3 d3_3 n_29 VDD VSS / XNOR2X1
Xg1022 d1_2 d3_2 n_28 VDD VSS / XNOR2X1
Xg1023 d1_1 d3_1 n_31 VDD VSS / CLKXOR2X1
Xg1024 d2_0 d3_0 n_30 VDD VSS / CLKXOR2X1
Xg1025 n_13 d3_2 n_27 VDD VSS / NAND2X1
Xg1026 n_15 d3_3 n_26 VDD VSS / NOR2X1
Xg1027 d3_0 d2_0 n_25 VDD VSS / NAND2X1
Xg1028 d3_1 d1_1 n_24 VDD VSS / NAND2X1
Xd3_reg_0 clk n_20 d3_0 VDD VSS / DFFQX1
Xd3_reg_2 clk n_19 d3_2 VDD VSS / DFFQX1
Xg1031 dw_1 d2_1 n_23 VDD VSS / XNOR2X1
Xd3_reg_1 clk n_21 d3_1 VDD VSS / DFFQX1
Xd3_reg_3 clk n_22 d3_3 VDD VSS / DFFQX1
Xg1034 n_1 d2_3 n_22 VDD VSS / AND2X1
Xg1035 n_1 d2_1 n_21 VDD VSS / AND2X1
Xg1036 n_1 d2_0 n_20 VDD VSS / AND2X1
Xg1037 n_1 d2_2 n_19 VDD VSS / AND2X1
Xg1038 d2_3 d1_3 n_18 VDD VSS / NOR2X1
Xg1039 dw_1 d2_1 n_17 VDD VSS / OR2X1
Xg1040 d2_2 d1_2 n_16 VDD VSS / NAND2X1
Xg1041 d1_3 d2_3 n_15 VDD VSS / AND2X1
Xg1042 d2_1 dw_1 n_14 VDD VSS / NAND2X1
Xg1043 d1_2 d2_2 n_13 VDD VSS / OR2X1
Xd2_reg_1 clk n_12 d2_1 VDD VSS / DFFQX1
Xd2_reg_2 clk n_9 d2_2 VDD VSS / DFFQX1
Xd2_reg_0 clk n_10 d2_0 VDD VSS / DFFQX1
Xd2_reg_3 clk n_11 d2_3 VDD VSS / DFFQX1
Xg1048 n_1 d1_1 n_12 VDD VSS / AND2X1
Xg1049 n_1 d1_3 n_11 VDD VSS / AND2X1
Xg1050 n_1 d1_0 n_10 VDD VSS / AND2X1
Xg1051 n_1 d1_2 n_9 VDD VSS / AND2X1
Xg1052 d1_0 dw_0 n_8 VDD VSS / NAND2X1
Xg1053 dw_0 d1_0 n_7 VDD VSS / OR2X1
Xd1_reg_1 clk n_4 d1_1 VDD VSS / DFFQX1
Xd1_reg_2 clk n_6 d1_2 VDD VSS / DFFQX1
Xd1_reg_3 clk n_5 d1_3 VDD VSS / DFFQX1
Xd1_reg_0 clk n_3 d1_0 VDD VSS / DFFQX1
Xg1058 res n_2 n_6 VDD VSS / NOR2X1
Xg1059 n_1 dw_3 n_5 VDD VSS / AND2X1
Xg1060 n_1 dw_1 n_4 VDD VSS / AND2X1
Xg1061 n_1 dw_0 n_3 VDD VSS / AND2X1
Xg1062 dw_2 n_2 VDD VSS / CLKINVX1
Xg1063 res n_1 VDD VSS / CLKINVX1
.ENDS dw_adder4_83

*******************************************************************************
* MODULE: dw_adder4_84
*******************************************************************************
.SUBCKT dw_adder4_84 clk res dw_0 dw_1 dw_2 dw_3 cap_dw_0 cap_dw_1 cap_dw_2 cap_dw_3 VDD VSS
Xcap_dw_reg_0 clk n_92 cap_dw_0 VDD VSS / DFFQX1
Xg959__4733 res n_91 n_92 VDD VSS / NOR2X1
Xcap_dw_reg_1 clk n_89 cap_dw_3 VDD VSS / DFFQX1
Xg961__6161 n_90 n_88 n_91 VDD VSS / NOR2X1
Xg962__9315 n_87 n_85 n_90 VDD VSS / NAND2X1
Xg963__9945 n_1 n_88 n_89 VDD VSS / AND2X1
Xg964__2883 n_86 n_74 n_88 VDD VSS / NOR2X1
Xg965__2346 n_84 n_81 n_87 VDD VSS / NOR2X1
Xg966__1666 n_83 n_73 n_86 VDD VSS / AND2X1
Xg967__7410 n_83 n_74 n_85 VDD VSS / NAND2X1
Xg968__6417 n_82 n_51 n_84 VDD VSS / NAND2X1
Xg969__5477 n_80 n_62 n_83 VDD VSS / NAND2X1
Xg970__2398 n_79 n_77 n_82 VDD VSS / NOR2X1
Xg971__5107 n_78 n_60 n_81 VDD VSS / NOR2X1
Xg972__6260 n_76 n_61 n_80 VDD VSS / NAND2X1
Xg973__4319 n_75 n_60 n_79 VDD VSS / AND2X1
Xg974__8428 n_71 n_64 n_78 VDD VSS / NOR2X1
Xg975__5526 n_69 n_68 n_77 VDD VSS / NAND2X1
Xg976__6783 n_72 n_65 n_76 VDD VSS / NAND2X1
Xg977__3680 n_70 n_71 n_75 VDD VSS / NAND2X1
Xg978__1617 n_67 n_35 n_73 VDD VSS / NAND2X1
Xg979__2802 n_64 n_60 n_72 VDD VSS / NAND2X1
Xg980__1705 n_67 n_35 n_74 VDD VSS / NOR2X1
Xg981__5122 n_63 n_65 n_70 VDD VSS / NAND2X1
Xg982__8246 n_64 n_66 n_69 VDD VSS / NAND2X1
Xg983__7098 n_43 n_57 n_68 VDD VSS / CLKXOR2X1
Xg984__6131 n_61 n_62 n_71 VDD VSS / AND2X1
Xg985 n_65 n_66 VDD VSS / CLKINVX1
Xg986 n_64 n_63 VDD VSS / CLKINVX1
Xg987__1881 n_58 n_47 n_67 VDD VSS / NOR2X1
Xg988__5115 n_56 n_45 n_65 VDD VSS / NAND2X1
Xg989__7482 n_59 n_50 n_64 VDD VSS / NAND2X1
Xg990__4733 n_53 n_54 n_62 VDD VSS / NAND2X1
Xg991__6161 n_52 n_55 n_61 VDD VSS / NAND2X1
Xg992__9315 n_45 n_56 n_60 VDD VSS / OR2X1
Xg993__9945 n_48 n_43 n_59 VDD VSS / NAND2X1
Xg994__2883 n_49 n_34 n_58 VDD VSS / AND2X1
Xg995__2346 n_48 n_50 n_57 VDD VSS / NAND2X1
Xg996 n_54 n_55 VDD VSS / CLKINVX1
Xg997 n_52 n_53 VDD VSS / CLKINVX1
Xg998__1666 dw_0 n_40 n_51 VDD VSS / CLKXOR2X1
Xg999__7410 n_36 n_42 n_56 VDD VSS / XNOR2X1
Xg1000__6417 n_46 n_32 n_54 VDD VSS / NAND2X1
Xg1001__5477 n_41 n_39 n_52 VDD VSS / CLKXOR2X1
Xg1002__2398 n_41 dw_3 n_49 VDD VSS / NAND2X1
Xg1003__5107 n_25 n_44 n_50 VDD VSS / OR2X1
Xg1004__6260 n_41 dw_3 n_47 VDD VSS / NOR2X1
Xg1005__4319 n_42 n_33 n_46 VDD VSS / NAND2X1
Xg1006__8428 n_44 n_25 n_48 VDD VSS / NAND2X1
Xg1007__5526 n_38 n_14 n_45 VDD VSS / NAND2X1
Xg1008__6783 n_23 n_31 n_44 VDD VSS / CLKXOR2X1
Xg1009__3680 n_37 n_8 n_43 VDD VSS / NAND2X1
Xg1010__1617 d1_0 n_30 n_40 VDD VSS / XNOR2X1
Xg1011__2802 dw_3 n_34 n_39 VDD VSS / XNOR2X1
Xg1012__1705 d2_2 n_28 n_42 VDD VSS / XNOR2X1
Xg1013__5122 d2_3 n_29 n_41 VDD VSS / XNOR2X1
Xg1014__8246 n_31 n_17 n_38 VDD VSS / NAND2X1
Xg1015__7098 n_30 n_7 n_37 VDD VSS / NAND2X1
Xg1016__6131 dw_2 n_24 n_36 VDD VSS / CLKXOR2X1
Xg1017__1881 n_24 n_2 n_33 VDD VSS / NAND2X1
Xg1018__5115 n_2 n_24 n_32 VDD VSS / OR2X1
Xg1019__7482 n_26 n_18 n_35 VDD VSS / NOR2X1
Xg1020__4733 n_27 n_16 n_34 VDD VSS / NAND2X1
Xg1021__6161 d1_3 d3_3 n_29 VDD VSS / XNOR2X1
Xg1022__9315 d1_2 d3_2 n_28 VDD VSS / XNOR2X1
Xg1023__9945 d1_1 d3_1 n_31 VDD VSS / CLKXOR2X1
Xg1024__2883 d2_0 d3_0 n_30 VDD VSS / CLKXOR2X1
Xg1025__2346 n_13 d3_2 n_27 VDD VSS / NAND2X1
Xg1026__1666 n_15 d3_3 n_26 VDD VSS / NOR2X1
Xg1027__7410 d3_0 d2_0 n_25 VDD VSS / NAND2X1
Xg1028__6417 d3_1 d1_1 n_24 VDD VSS / NAND2X1
Xd3_reg_0 clk n_20 d3_0 VDD VSS / DFFQX1
Xd3_reg_2 clk n_19 d3_2 VDD VSS / DFFQX1
Xg1031__5477 dw_1 d2_1 n_23 VDD VSS / XNOR2X1
Xd3_reg_1 clk n_21 d3_1 VDD VSS / DFFQX1
Xd3_reg_3 clk n_22 d3_3 VDD VSS / DFFQX1
Xg1034__2398 n_1 d2_3 n_22 VDD VSS / AND2X1
Xg1035__5107 n_1 d2_1 n_21 VDD VSS / AND2X1
Xg1036__6260 n_1 d2_0 n_20 VDD VSS / AND2X1
Xg1037__4319 n_1 d2_2 n_19 VDD VSS / AND2X1
Xg1038__8428 d2_3 d1_3 n_18 VDD VSS / NOR2X1
Xg1039__5526 dw_1 d2_1 n_17 VDD VSS / OR2X1
Xg1040__6783 d2_2 d1_2 n_16 VDD VSS / NAND2X1
Xg1041__3680 d1_3 d2_3 n_15 VDD VSS / AND2X1
Xg1042__1617 d2_1 dw_1 n_14 VDD VSS / NAND2X1
Xg1043__2802 d1_2 d2_2 n_13 VDD VSS / OR2X1
Xd2_reg_1 clk n_12 d2_1 VDD VSS / DFFQX1
Xd2_reg_2 clk n_9 d2_2 VDD VSS / DFFQX1
Xd2_reg_0 clk n_10 d2_0 VDD VSS / DFFQX1
Xd2_reg_3 clk n_11 d2_3 VDD VSS / DFFQX1
Xg1048__1705 n_1 d1_1 n_12 VDD VSS / AND2X1
Xg1049__5122 n_1 d1_3 n_11 VDD VSS / AND2X1
Xg1050__8246 n_1 d1_0 n_10 VDD VSS / AND2X1
Xg1051__7098 n_1 d1_2 n_9 VDD VSS / AND2X1
Xg1052__6131 d1_0 dw_0 n_8 VDD VSS / NAND2X1
Xg1053__1881 dw_0 d1_0 n_7 VDD VSS / OR2X1
Xd1_reg_1 clk n_4 d1_1 VDD VSS / DFFQX1
Xd1_reg_2 clk n_6 d1_2 VDD VSS / DFFQX1
Xd1_reg_3 clk n_5 d1_3 VDD VSS / DFFQX1
Xd1_reg_0 clk n_3 d1_0 VDD VSS / DFFQX1
Xg1058__5115 res n_2 n_6 VDD VSS / NOR2X1
Xg1059__7482 n_1 dw_3 n_5 VDD VSS / AND2X1
Xg1060__4733 n_1 dw_1 n_4 VDD VSS / AND2X1
Xg1061__6161 n_1 dw_0 n_3 VDD VSS / AND2X1
Xg1062 dw_2 n_2 VDD VSS / CLKINVX1
Xg1063 res n_1 VDD VSS / CLKINVX1
.ENDS dw_adder4_84

*******************************************************************************
* MODULE: dw_adder4_85
*******************************************************************************
.SUBCKT dw_adder4_85 clk res dw_0 dw_1 dw_2 dw_3 cap_dw_0 cap_dw_1 cap_dw_2 cap_dw_3 VDD VSS
Xcap_dw_reg_0 clk n_92 cap_dw_0 VDD VSS / DFFQX1
Xg959 res n_91 n_92 VDD VSS / NOR2X1
Xcap_dw_reg_1 clk n_89 cap_dw_3 VDD VSS / DFFQX1
Xg961 n_90 n_88 n_91 VDD VSS / NOR2X1
Xg962 n_87 n_85 n_90 VDD VSS / NAND2X1
Xg963 n_1 n_88 n_89 VDD VSS / AND2X1
Xg964 n_86 n_74 n_88 VDD VSS / NOR2X1
Xg965 n_84 n_81 n_87 VDD VSS / NOR2X1
Xg966 n_83 n_73 n_86 VDD VSS / AND2X1
Xg967 n_83 n_74 n_85 VDD VSS / NAND2X1
Xg968 n_82 n_51 n_84 VDD VSS / NAND2X1
Xg969 n_80 n_62 n_83 VDD VSS / NAND2X1
Xg970 n_79 n_77 n_82 VDD VSS / NOR2X1
Xg971 n_78 n_60 n_81 VDD VSS / NOR2X1
Xg972 n_76 n_61 n_80 VDD VSS / NAND2X1
Xg973 n_75 n_60 n_79 VDD VSS / AND2X1
Xg974 n_71 n_64 n_78 VDD VSS / NOR2X1
Xg975 n_69 n_68 n_77 VDD VSS / NAND2X1
Xg976 n_72 n_65 n_76 VDD VSS / NAND2X1
Xg977 n_70 n_71 n_75 VDD VSS / NAND2X1
Xg978 n_67 n_35 n_73 VDD VSS / NAND2X1
Xg979 n_64 n_60 n_72 VDD VSS / NAND2X1
Xg980 n_67 n_35 n_74 VDD VSS / NOR2X1
Xg981 n_63 n_65 n_70 VDD VSS / NAND2X1
Xg982 n_64 n_66 n_69 VDD VSS / NAND2X1
Xg983 n_43 n_57 n_68 VDD VSS / CLKXOR2X1
Xg984 n_61 n_62 n_71 VDD VSS / AND2X1
Xg985 n_65 n_66 VDD VSS / CLKINVX1
Xg986 n_64 n_63 VDD VSS / CLKINVX1
Xg987 n_58 n_47 n_67 VDD VSS / NOR2X1
Xg988 n_56 n_45 n_65 VDD VSS / NAND2X1
Xg989 n_59 n_50 n_64 VDD VSS / NAND2X1
Xg990 n_53 n_54 n_62 VDD VSS / NAND2X1
Xg991 n_52 n_55 n_61 VDD VSS / NAND2X1
Xg992 n_45 n_56 n_60 VDD VSS / OR2X1
Xg993 n_48 n_43 n_59 VDD VSS / NAND2X1
Xg994 n_49 n_34 n_58 VDD VSS / AND2X1
Xg995 n_48 n_50 n_57 VDD VSS / NAND2X1
Xg996 n_54 n_55 VDD VSS / CLKINVX1
Xg997 n_52 n_53 VDD VSS / CLKINVX1
Xg998 dw_0 n_40 n_51 VDD VSS / CLKXOR2X1
Xg999 n_36 n_42 n_56 VDD VSS / XNOR2X1
Xg1000 n_46 n_32 n_54 VDD VSS / NAND2X1
Xg1001 n_41 n_39 n_52 VDD VSS / CLKXOR2X1
Xg1002 n_41 dw_3 n_49 VDD VSS / NAND2X1
Xg1003 n_25 n_44 n_50 VDD VSS / OR2X1
Xg1004 n_41 dw_3 n_47 VDD VSS / NOR2X1
Xg1005 n_42 n_33 n_46 VDD VSS / NAND2X1
Xg1006 n_44 n_25 n_48 VDD VSS / NAND2X1
Xg1007 n_38 n_14 n_45 VDD VSS / NAND2X1
Xg1008 n_23 n_31 n_44 VDD VSS / CLKXOR2X1
Xg1009 n_37 n_8 n_43 VDD VSS / NAND2X1
Xg1010 d1_0 n_30 n_40 VDD VSS / XNOR2X1
Xg1011 dw_3 n_34 n_39 VDD VSS / XNOR2X1
Xg1012 d2_2 n_28 n_42 VDD VSS / XNOR2X1
Xg1013 d2_3 n_29 n_41 VDD VSS / XNOR2X1
Xg1014 n_31 n_17 n_38 VDD VSS / NAND2X1
Xg1015 n_30 n_7 n_37 VDD VSS / NAND2X1
Xg1016 dw_2 n_24 n_36 VDD VSS / CLKXOR2X1
Xg1017 n_24 n_2 n_33 VDD VSS / NAND2X1
Xg1018 n_2 n_24 n_32 VDD VSS / OR2X1
Xg1019 n_26 n_18 n_35 VDD VSS / NOR2X1
Xg1020 n_27 n_16 n_34 VDD VSS / NAND2X1
Xg1021 d1_3 d3_3 n_29 VDD VSS / XNOR2X1
Xg1022 d1_2 d3_2 n_28 VDD VSS / XNOR2X1
Xg1023 d1_1 d3_1 n_31 VDD VSS / CLKXOR2X1
Xg1024 d2_0 d3_0 n_30 VDD VSS / CLKXOR2X1
Xg1025 n_13 d3_2 n_27 VDD VSS / NAND2X1
Xg1026 n_15 d3_3 n_26 VDD VSS / NOR2X1
Xg1027 d3_0 d2_0 n_25 VDD VSS / NAND2X1
Xg1028 d3_1 d1_1 n_24 VDD VSS / NAND2X1
Xd3_reg_0 clk n_20 d3_0 VDD VSS / DFFQX1
Xd3_reg_2 clk n_19 d3_2 VDD VSS / DFFQX1
Xg1031 dw_1 d2_1 n_23 VDD VSS / XNOR2X1
Xd3_reg_1 clk n_21 d3_1 VDD VSS / DFFQX1
Xd3_reg_3 clk n_22 d3_3 VDD VSS / DFFQX1
Xg1034 n_1 d2_3 n_22 VDD VSS / AND2X1
Xg1035 n_1 d2_1 n_21 VDD VSS / AND2X1
Xg1036 n_1 d2_0 n_20 VDD VSS / AND2X1
Xg1037 n_1 d2_2 n_19 VDD VSS / AND2X1
Xg1038 d2_3 d1_3 n_18 VDD VSS / NOR2X1
Xg1039 dw_1 d2_1 n_17 VDD VSS / OR2X1
Xg1040 d2_2 d1_2 n_16 VDD VSS / NAND2X1
Xg1041 d1_3 d2_3 n_15 VDD VSS / AND2X1
Xg1042 d2_1 dw_1 n_14 VDD VSS / NAND2X1
Xg1043 d1_2 d2_2 n_13 VDD VSS / OR2X1
Xd2_reg_1 clk n_12 d2_1 VDD VSS / DFFQX1
Xd2_reg_2 clk n_9 d2_2 VDD VSS / DFFQX1
Xd2_reg_0 clk n_10 d2_0 VDD VSS / DFFQX1
Xd2_reg_3 clk n_11 d2_3 VDD VSS / DFFQX1
Xg1048 n_1 d1_1 n_12 VDD VSS / AND2X1
Xg1049 n_1 d1_3 n_11 VDD VSS / AND2X1
Xg1050 n_1 d1_0 n_10 VDD VSS / AND2X1
Xg1051 n_1 d1_2 n_9 VDD VSS / AND2X1
Xg1052 d1_0 dw_0 n_8 VDD VSS / NAND2X1
Xg1053 dw_0 d1_0 n_7 VDD VSS / OR2X1
Xd1_reg_1 clk n_4 d1_1 VDD VSS / DFFQX1
Xd1_reg_2 clk n_6 d1_2 VDD VSS / DFFQX1
Xd1_reg_3 clk n_5 d1_3 VDD VSS / DFFQX1
Xd1_reg_0 clk n_3 d1_0 VDD VSS / DFFQX1
Xg1058 res n_2 n_6 VDD VSS / NOR2X1
Xg1059 n_1 dw_3 n_5 VDD VSS / AND2X1
Xg1060 n_1 dw_1 n_4 VDD VSS / AND2X1
Xg1061 n_1 dw_0 n_3 VDD VSS / AND2X1
Xg1062 dw_2 n_2 VDD VSS / CLKINVX1
Xg1063 res n_1 VDD VSS / CLKINVX1
.ENDS dw_adder4_85

*******************************************************************************
* MODULE: db_adder4
*******************************************************************************
.SUBCKT db_adder4 clk res delta_0 delta_1 delta_2 delta_3 cap_db_0 cap_db_1 cap_db_2 cap_db_3 VDD VSS
Xcap_db_reg_0 clk n_92 cap_db_0 VDD VSS / DFFQX1
Xg959__8428 res n_91 n_92 VDD VSS / NOR2X1
Xcap_db_reg_1 clk n_89 cap_db_3 VDD VSS / DFFQX1
Xg961__5526 n_90 n_88 n_91 VDD VSS / NOR2X1
Xg962__6783 n_87 n_85 n_90 VDD VSS / NAND2X1
Xg963__3680 n_1 n_88 n_89 VDD VSS / AND2X1
Xg964__1617 n_86 n_74 n_88 VDD VSS / NOR2X1
Xg965__2802 n_84 n_81 n_87 VDD VSS / NOR2X1
Xg966__1705 n_83 n_73 n_86 VDD VSS / AND2X1
Xg967__5122 n_83 n_74 n_85 VDD VSS / NAND2X1
Xg968__8246 n_82 n_51 n_84 VDD VSS / NAND2X1
Xg969__7098 n_80 n_62 n_83 VDD VSS / NAND2X1
Xg970__6131 n_79 n_77 n_82 VDD VSS / NOR2X1
Xg971__1881 n_78 n_60 n_81 VDD VSS / NOR2X1
Xg972__5115 n_76 n_61 n_80 VDD VSS / NAND2X1
Xg973__7482 n_75 n_60 n_79 VDD VSS / AND2X1
Xg974__4733 n_71 n_64 n_78 VDD VSS / NOR2X1
Xg975__6161 n_69 n_68 n_77 VDD VSS / NAND2X1
Xg976__9315 n_72 n_65 n_76 VDD VSS / NAND2X1
Xg977__9945 n_70 n_71 n_75 VDD VSS / NAND2X1
Xg978__2883 n_67 n_35 n_73 VDD VSS / NAND2X1
Xg979__2346 n_64 n_60 n_72 VDD VSS / NAND2X1
Xg980__1666 n_67 n_35 n_74 VDD VSS / NOR2X1
Xg981__7410 n_63 n_65 n_70 VDD VSS / NAND2X1
Xg982__6417 n_64 n_66 n_69 VDD VSS / NAND2X1
Xg983__5477 n_43 n_57 n_68 VDD VSS / CLKXOR2X1
Xg984__2398 n_61 n_62 n_71 VDD VSS / AND2X1
Xg985 n_65 n_66 VDD VSS / CLKINVX1
Xg986 n_64 n_63 VDD VSS / CLKINVX1
Xg987__5107 n_58 n_47 n_67 VDD VSS / NOR2X1
Xg988__6260 n_56 n_45 n_65 VDD VSS / NAND2X1
Xg989__4319 n_59 n_50 n_64 VDD VSS / NAND2X1
Xg990__8428 n_53 n_54 n_62 VDD VSS / NAND2X1
Xg991__5526 n_52 n_55 n_61 VDD VSS / NAND2X1
Xg992__6783 n_45 n_56 n_60 VDD VSS / OR2X1
Xg993__3680 n_48 n_43 n_59 VDD VSS / NAND2X1
Xg994__1617 n_49 n_34 n_58 VDD VSS / AND2X1
Xg995__2802 n_48 n_50 n_57 VDD VSS / NAND2X1
Xg996 n_54 n_55 VDD VSS / CLKINVX1
Xg997 n_52 n_53 VDD VSS / CLKINVX1
Xg998__1705 delta_0 n_40 n_51 VDD VSS / CLKXOR2X1
Xg999__5122 n_36 n_42 n_56 VDD VSS / XNOR2X1
Xg1000__8246 n_46 n_32 n_54 VDD VSS / NAND2X1
Xg1001__7098 n_41 n_39 n_52 VDD VSS / CLKXOR2X1
Xg1002__6131 n_41 delta_3 n_49 VDD VSS / NAND2X1
Xg1003__1881 n_25 n_44 n_50 VDD VSS / OR2X1
Xg1004__5115 n_41 delta_3 n_47 VDD VSS / NOR2X1
Xg1005__7482 n_42 n_33 n_46 VDD VSS / NAND2X1
Xg1006__4733 n_44 n_25 n_48 VDD VSS / NAND2X1
Xg1007__6161 n_38 n_14 n_45 VDD VSS / NAND2X1
Xg1008__9315 n_23 n_31 n_44 VDD VSS / CLKXOR2X1
Xg1009__9945 n_37 n_8 n_43 VDD VSS / NAND2X1
Xg1010__2883 d1_0 n_30 n_40 VDD VSS / XNOR2X1
Xg1011__2346 delta_3 n_34 n_39 VDD VSS / XNOR2X1
Xg1012__1666 d2_2 n_28 n_42 VDD VSS / XNOR2X1
Xg1013__7410 d2_3 n_29 n_41 VDD VSS / XNOR2X1
Xg1014__6417 n_31 n_17 n_38 VDD VSS / NAND2X1
Xg1015__5477 n_30 n_7 n_37 VDD VSS / NAND2X1
Xg1016__2398 delta_2 n_24 n_36 VDD VSS / CLKXOR2X1
Xg1017__5107 n_24 n_2 n_33 VDD VSS / NAND2X1
Xg1018__6260 n_2 n_24 n_32 VDD VSS / OR2X1
Xg1019__4319 n_26 n_18 n_35 VDD VSS / NOR2X1
Xg1020__8428 n_27 n_16 n_34 VDD VSS / NAND2X1
Xg1021__5526 d1_3 d3_3 n_29 VDD VSS / XNOR2X1
Xg1022__6783 d1_2 d3_2 n_28 VDD VSS / XNOR2X1
Xg1023__3680 d1_1 d3_1 n_31 VDD VSS / CLKXOR2X1
Xg1024__1617 d2_0 d3_0 n_30 VDD VSS / CLKXOR2X1
Xg1025__2802 n_13 d3_2 n_27 VDD VSS / NAND2X1
Xg1026__1705 n_15 d3_3 n_26 VDD VSS / NOR2X1
Xg1027__5122 d3_0 d2_0 n_25 VDD VSS / NAND2X1
Xg1028__8246 d3_1 d1_1 n_24 VDD VSS / NAND2X1
Xd3_reg_0 clk n_20 d3_0 VDD VSS / DFFQX1
Xd3_reg_2 clk n_19 d3_2 VDD VSS / DFFQX1
Xg1031__7098 delta_1 d2_1 n_23 VDD VSS / XNOR2X1
Xd3_reg_1 clk n_21 d3_1 VDD VSS / DFFQX1
Xd3_reg_3 clk n_22 d3_3 VDD VSS / DFFQX1
Xg1034__6131 n_1 d2_3 n_22 VDD VSS / AND2X1
Xg1035__1881 n_1 d2_1 n_21 VDD VSS / AND2X1
Xg1036__5115 n_1 d2_0 n_20 VDD VSS / AND2X1
Xg1037__7482 n_1 d2_2 n_19 VDD VSS / AND2X1
Xg1038__4733 d2_3 d1_3 n_18 VDD VSS / NOR2X1
Xg1039__6161 delta_1 d2_1 n_17 VDD VSS / OR2X1
Xg1040__9315 d2_2 d1_2 n_16 VDD VSS / NAND2X1
Xg1041__9945 d1_3 d2_3 n_15 VDD VSS / AND2X1
Xg1042__2883 d2_1 delta_1 n_14 VDD VSS / NAND2X1
Xg1043__2346 d1_2 d2_2 n_13 VDD VSS / OR2X1
Xd2_reg_1 clk n_12 d2_1 VDD VSS / DFFQX1
Xd2_reg_2 clk n_9 d2_2 VDD VSS / DFFQX1
Xd2_reg_0 clk n_10 d2_0 VDD VSS / DFFQX1
Xd2_reg_3 clk n_11 d2_3 VDD VSS / DFFQX1
Xg1048__1666 n_1 d1_1 n_12 VDD VSS / AND2X1
Xg1049__7410 n_1 d1_3 n_11 VDD VSS / AND2X1
Xg1050__6417 n_1 d1_0 n_10 VDD VSS / AND2X1
Xg1051__5477 n_1 d1_2 n_9 VDD VSS / AND2X1
Xg1052__2398 d1_0 delta_0 n_8 VDD VSS / NAND2X1
Xg1053__5107 delta_0 d1_0 n_7 VDD VSS / OR2X1
Xd1_reg_1 clk n_4 d1_1 VDD VSS / DFFQX1
Xd1_reg_2 clk n_6 d1_2 VDD VSS / DFFQX1
Xd1_reg_3 clk n_5 d1_3 VDD VSS / DFFQX1
Xd1_reg_0 clk n_3 d1_0 VDD VSS / DFFQX1
Xg1058__6260 res n_2 n_6 VDD VSS / NOR2X1
Xg1059__4319 n_1 delta_3 n_5 VDD VSS / AND2X1
Xg1060__8428 n_1 delta_1 n_4 VDD VSS / AND2X1
Xg1061__5526 n_1 delta_0 n_3 VDD VSS / AND2X1
Xg1062 delta_2 n_2 VDD VSS / CLKINVX1
Xg1063 res n_1 VDD VSS / CLKINVX1
.ENDS db_adder4

*******************************************************************************
* MODULE: db_adder4_40
*******************************************************************************
.SUBCKT db_adder4_40 clk res delta_0 delta_1 delta_2 delta_3 cap_db_0 cap_db_1 cap_db_2 cap_db_3 VDD VSS
Xcap_db_reg_0 clk n_22 cap_db_0 VDD VSS / DFFQX1
Xg342__5122 res n_21 n_22 VDD VSS / NOR2X1
Xg343__8246 n_20 d2_2 n_21 VDD VSS / NOR2X1
Xg344__7098 d1_2 n_19 n_20 VDD VSS / OR2X1
Xg345__6131 d2_1 n_18 n_19 VDD VSS / OR2X1
Xg346__1881 d2_0 n_17 n_18 VDD VSS / OR2X1
Xg347__5115 delta_2 n_16 n_17 VDD VSS / OR2X1
Xg348__7482 delta_1 n_15 n_16 VDD VSS / OR2X1
Xg349__4733 d1_0 n_14 n_15 VDD VSS / OR2X1
Xg350__6161 delta_0 n_13 n_14 VDD VSS / OR2X1
Xg351__9315 d1_1 n_12 n_13 VDD VSS / OR2X1
Xg352__9945 d3_1 n_11 n_12 VDD VSS / OR2X1
Xg353__2883 d3_2 d3_0 n_11 VDD VSS / OR2X1
Xd3_reg_1 clk n_8 d3_1 VDD VSS / DFFQX1
Xd3_reg_2 clk n_10 d3_2 VDD VSS / DFFQX1
Xd3_reg_0 clk n_9 d3_0 VDD VSS / DFFQX1
Xg357__2346 n_1 d2_2 n_10 VDD VSS / AND2X1
Xg358__1666 n_1 d2_0 n_9 VDD VSS / AND2X1
Xg359__7410 n_1 d2_1 n_8 VDD VSS / AND2X1
Xd2_reg_0 clk n_7 d2_0 VDD VSS / DFFQX1
Xd2_reg_2 clk n_5 d2_2 VDD VSS / DFFQX1
Xd2_reg_1 clk n_6 d2_1 VDD VSS / DFFQX1
Xg363__6417 n_1 d1_0 n_7 VDD VSS / AND2X1
Xg364__5477 n_1 d1_1 n_6 VDD VSS / AND2X1
Xg365__2398 n_1 d1_2 n_5 VDD VSS / AND2X1
Xd1_reg_0 clk n_2 d1_0 VDD VSS / DFFQX1
Xd1_reg_1 clk n_3 d1_1 VDD VSS / DFFQX1
Xd1_reg_2 clk n_4 d1_2 VDD VSS / DFFQX1
Xg369__5107 n_1 delta_2 n_4 VDD VSS / AND2X1
Xg370__6260 n_1 delta_1 n_3 VDD VSS / AND2X1
Xg371__4319 n_1 delta_0 n_2 VDD VSS / AND2X1
Xg372 res n_1 VDD VSS / CLKINVX1
.ENDS db_adder4_40

*******************************************************************************
* MODULE: db_adder4_41
*******************************************************************************
.SUBCKT db_adder4_41 clk res delta_0 delta_1 delta_2 delta_3 cap_db_0 cap_db_1 cap_db_2 cap_db_3 VDD VSS
Xcap_db_reg_0 clk n_22 cap_db_0 VDD VSS / DFFQX1
Xg342__4733 res n_21 n_22 VDD VSS / NOR2X1
Xg343__6161 n_20 d2_2 n_21 VDD VSS / NOR2X1
Xg344__9315 d1_2 n_19 n_20 VDD VSS / OR2X1
Xg345__9945 d2_1 n_18 n_19 VDD VSS / OR2X1
Xg346__2883 d2_0 n_17 n_18 VDD VSS / OR2X1
Xg347__2346 delta_2 n_16 n_17 VDD VSS / OR2X1
Xg348__1666 delta_1 n_15 n_16 VDD VSS / OR2X1
Xg349__7410 d1_0 n_14 n_15 VDD VSS / OR2X1
Xg350__6417 delta_0 n_13 n_14 VDD VSS / OR2X1
Xg351__5477 d1_1 n_12 n_13 VDD VSS / OR2X1
Xg352__2398 d3_1 n_11 n_12 VDD VSS / OR2X1
Xg353__5107 d3_2 d3_0 n_11 VDD VSS / OR2X1
Xd3_reg_1 clk n_8 d3_1 VDD VSS / DFFQX1
Xd3_reg_2 clk n_10 d3_2 VDD VSS / DFFQX1
Xd3_reg_0 clk n_9 d3_0 VDD VSS / DFFQX1
Xg357__6260 n_1 d2_2 n_10 VDD VSS / AND2X1
Xg358__4319 n_1 d2_0 n_9 VDD VSS / AND2X1
Xg359__8428 n_1 d2_1 n_8 VDD VSS / AND2X1
Xd2_reg_0 clk n_7 d2_0 VDD VSS / DFFQX1
Xd2_reg_2 clk n_5 d2_2 VDD VSS / DFFQX1
Xd2_reg_1 clk n_6 d2_1 VDD VSS / DFFQX1
Xg363__5526 n_1 d1_0 n_7 VDD VSS / AND2X1
Xg364__6783 n_1 d1_1 n_6 VDD VSS / AND2X1
Xg365__3680 n_1 d1_2 n_5 VDD VSS / AND2X1
Xd1_reg_0 clk n_2 d1_0 VDD VSS / DFFQX1
Xd1_reg_1 clk n_3 d1_1 VDD VSS / DFFQX1
Xd1_reg_2 clk n_4 d1_2 VDD VSS / DFFQX1
Xg369__1617 n_1 delta_2 n_4 VDD VSS / AND2X1
Xg370__2802 n_1 delta_1 n_3 VDD VSS / AND2X1
Xg371__1705 n_1 delta_0 n_2 VDD VSS / AND2X1
Xg372 res n_1 VDD VSS / CLKINVX1
.ENDS db_adder4_41

*******************************************************************************
* MODULE: backward4  (TOP of backward4.cdl)
* All sub-modules defined above. Instantiates dadz, delta, dw, dw_adder,
* db_adder, delay chains. Buffer inverters handle reset fanout.
*******************************************************************************
.SUBCKT backward4 clk res
+ a3_1_0 a3_1_1 a3_1_2 a3_1_3
+ a2_1_0 a2_1_1 a2_1_2 a2_1_3
+ a2_2_0 a2_2_1 a2_2_2 a2_2_3
+ k1_0 k1_1 k1_2 k1_3
+ k2_0 k2_1 k2_2 k2_3
+ t1_0 t1_1 t1_2 t1_3
+ w3_11_0 w3_11_1 w3_11_2 w3_11_3
+ w3_21_0 w3_21_1 w3_21_2 w3_21_3
+ cap_dw3_11_0 cap_dw3_11_1 cap_dw3_11_2 cap_dw3_11_3
+ cap_dw3_21_0 cap_dw3_21_1 cap_dw3_21_2 cap_dw3_21_3
+ cap_dw2_11_0 cap_dw2_11_1 cap_dw2_11_2 cap_dw2_11_3
+ cap_dw2_21_0 cap_dw2_21_1 cap_dw2_21_2 cap_dw2_21_3
+ cap_dw2_12_0 cap_dw2_12_1 cap_dw2_12_2 cap_dw2_12_3
+ cap_dw2_22_0 cap_dw2_22_1 cap_dw2_22_2 cap_dw2_22_3
+ cap_db3_1_0 cap_db3_1_1 cap_db3_1_2 cap_db3_1_3
+ cap_db2_1_0 cap_db2_1_1 cap_db2_1_2 cap_db2_1_3
+ cap_db2_2_0 cap_db2_2_1 cap_db2_2_2 cap_db2_2_3
+ VDD VSS

*--- Reset fanout buffer inverters ---*
* n_0=~res, n_1=~res (two separate trees for fanout)
Xg45 res n_0 VDD VSS / CLKINVX1
Xg15 res n_1 VDD VSS / CLKINVX1
* n_0 tree
Xg27 n_0 n_20 VDD VSS / CLKINVX1
Xg31 n_0 n_25 VDD VSS / CLKINVX1
Xg35 n_0 n_30 VDD VSS / CLKINVX1
Xg34 n_0 n_28 VDD VSS / CLKINVX1
Xg39 n_0 n_38 VDD VSS / CLKINVX1
Xg42 n_0 n_35 VDD VSS / CLKINVX1
Xg41 n_0 n_27 VDD VSS / CLKINVX1
Xg29 n_0 n_5 VDD VSS / CLKINVX1
Xg22 n_0 n_7 VDD VSS / CLKINVX1
Xg37 n_0 n_3 VDD VSS / CLKINVX1
Xg44 n_0 n_6 VDD VSS / CLKINVX1
* n_1 tree
Xg9 n_1 n_31 VDD VSS / CLKINVX1
Xg8 n_1 n_36 VDD VSS / CLKINVX1
Xg12 n_1 n_44 VDD VSS / CLKINVX1
Xg1 n_1 n_33 VDD VSS / CLKINVX1
Xg2 n_1 n_34 VDD VSS / CLKINVX1
Xg5 n_1 n_32 VDD VSS / CLKINVX1
Xg7 n_1 n_4 VDD VSS / CLKINVX1
Xg14 n_1 n_8 VDD VSS / CLKINVX1

*--- a2_1 delay chain (3 stages) ---*
XDA2_1_1 clk n_6 a2_1_0 a2_1_1 a2_1_2 a2_1_3 tmp_a2_1_0 tmp_a2_1_1 tmp_a2_1_2 tmp_a2_1_3 VDD VSS / delay1_4_389
XDA2_1_2 clk n_25 tmp_a2_1_0 tmp_a2_1_1 tmp_a2_1_2 tmp_a2_1_3 tmp2_a2_1_0 tmp2_a2_1_1 tmp2_a2_1_2 tmp2_a2_1_3 VDD VSS / delay1_4_387
XDA2_1_3 clk n_28 tmp2_a2_1_0 tmp2_a2_1_1 tmp2_a2_1_2 tmp2_a2_1_3 tmp3_a2_1_0 tmp3_a2_1_1 tmp3_a2_1_2 tmp3_a2_1_3 VDD VSS / delay1_4_385

*--- a2_2 delay chain (3 stages) ---*
XDA2_2_1 clk n_7 a2_2_0 a2_2_1 a2_2_2 a2_2_3 tmp_a2_2_0 tmp_a2_2_1 tmp_a2_2_2 tmp_a2_2_3 VDD VSS / delay1_4_388
XDA2_2_2 clk n_36 tmp_a2_2_0 tmp_a2_2_1 tmp_a2_2_2 tmp_a2_2_3 tmp2_a2_2_0 tmp2_a2_2_1 tmp2_a2_2_2 tmp2_a2_2_3 VDD VSS / delay1_4_386
XDA2_2_3 clk n_32 tmp2_a2_2_0 tmp2_a2_2_1 tmp2_a2_2_2 tmp2_a2_2_3 tmp3_a2_2_0 tmp3_a2_2_1 tmp3_a2_2_2 tmp3_a2_2_3 VDD VSS / delay1_4_384

*--- a3_1 delay (1 stage) ---*
XDA3 clk n_4 a3_1_0 a3_1_1 a3_1_2 a3_1_3 tmp_a3_1_0 tmp_a3_1_1 tmp_a3_1_2 tmp_a3_1_3 VDD VSS / delay1_4

*--- dadz computation ---*
* DADZ2_1: a={UNC_Z,a2_1[2:0]} dadz={UNC0,UNC,dadz2_1[1:0]}
XDADZ2_1 clk n_44 a2_1_0 a2_1_1 a2_1_2 UNCONNECTED_HIER_Z dadz2_1_0 dadz2_1_1 UNCONNECTED UNCONNECTED0 VDD VSS / dadz4_39
* DADZ2_2: a={UNC_Z0,a2_2[2:0]} dadz={UNC2,UNC1,dadz2_2[1:0]}
XDADZ2_2 clk n_44 a2_2_0 a2_2_1 a2_2_2 UNCONNECTED_HIER_Z0 dadz2_2_0 dadz2_2_1 UNCONNECTED1 UNCONNECTED2 VDD VSS / dadz4_38
* DADZ3_1: a={UNC_Z1,a3_1[2:0]} dadz={dadz3_1[3],UNC3,dadz3_1[1:0]}
XDADZ3_1 clk n_5 a3_1_0 a3_1_1 a3_1_2 UNCONNECTED_HIER_Z1 dadz3_1_0 dadz3_1_1 UNCONNECTED3 dadz3_1_3 VDD VSS / dadz4

*--- k1 delay chain (3 stages) ---*
XDK1_1 clk n_27 k1_0 k1_1 k1_2 k1_3 tmp_k1_0 tmp_k1_1 tmp_k1_2 tmp_k1_3 VDD VSS / delay1_4_383
XDK1_2 clk n_7 tmp_k1_0 tmp_k1_1 tmp_k1_2 tmp_k1_3 tmp2_k1_0 tmp2_k1_1 tmp2_k1_2 tmp2_k1_3 VDD VSS / delay1_4_382
XDK1_3 clk n_4 tmp2_k1_0 tmp2_k1_1 tmp2_k1_2 tmp2_k1_3 tmp3_k1_0 tmp3_k1_1 tmp3_k1_2 tmp3_k1_3 VDD VSS / delay1_4_381

*--- k2 delay chain (3 stages) ---*
XDK2_1 clk n_33 k2_0 k2_1 k2_2 k2_3 tmp_k2_0 tmp_k2_1 tmp_k2_2 tmp_k2_3 VDD VSS / delay1_4_380
XDK2_2 clk n_38 tmp_k2_0 tmp_k2_1 tmp_k2_2 tmp_k2_3 tmp2_k2_0 tmp2_k2_1 tmp2_k2_2 tmp2_k2_3 VDD VSS / delay1_4_379
XDK2_3 clk n_3 tmp2_k2_0 tmp2_k2_1 tmp2_k2_2 tmp2_k2_3 tmp3_k2_0 tmp3_k2_1 tmp3_k2_2 tmp3_k2_3 VDD VSS / delay1_4_378

*--- t1 delay: in={UNC_Z21,UNC_Z20,UNC_Z19,t1[0]} out={UNC20,tmp_t1[2],UNC19,UNC18} ---*
XDT1 clk n_5 t1_0 UNCONNECTED_HIER_Z19 UNCONNECTED_HIER_Z20 UNCONNECTED_HIER_Z21 UNCONNECTED18 UNCONNECTED19 tmp_t1_2 UNCONNECTED20 VDD VSS / delay1_4_1

*--- w3_11 delay chain (2 stages) ---*
XDW3_11_1 clk n_20 w3_11_0 w3_11_1 w3_11_2 w3_11_3 tmp_w3_11_0 tmp_w3_11_1 tmp_w3_11_2 tmp_w3_11_3 VDD VSS / delay1_4_395
XDW3_11_2 clk n_33 tmp_w3_11_0 tmp_w3_11_1 tmp_w3_11_2 tmp_w3_11_3 tmp2_w3_11_0 tmp2_w3_11_1 tmp2_w3_11_2 tmp2_w3_11_3 VDD VSS / delay1_4_393

*--- w3_21 delay chain (2 stages) ---*
XDW3_21_1 clk n_7 w3_21_0 w3_21_1 w3_21_2 w3_21_3 tmp_w3_21_0 tmp_w3_21_1 tmp_w3_21_2 tmp_w3_21_3 VDD VSS / delay1_4_394
XDW3_21_2 clk n_31 tmp_w3_21_0 tmp_w3_21_1 tmp_w3_21_2 tmp_w3_21_3 tmp2_w3_21_0 tmp2_w3_21_1 tmp2_w3_21_2 tmp2_w3_21_3 VDD VSS / delay1_4_392

*--- delta3 computation ---*
* DELTA3_1: t={UNC_Z16,UNC_Z15,UNC_Z14,tmp_t1[2]} dadz={UNC_Z18,UNC_Z17,dadz3_1[1:0]}
XDELTA3_1 clk n_8
+ tmp_a3_1_0 tmp_a3_1_1 tmp_a3_1_2 tmp_a3_1_3
+ tmp_t1_2 UNCONNECTED_HIER_Z14 UNCONNECTED_HIER_Z15 UNCONNECTED_HIER_Z16
+ dadz3_1_0 dadz3_1_1 UNCONNECTED_HIER_Z17 UNCONNECTED_HIER_Z18
+ delta3_1_0 delta3_1_1 delta3_1_2 delta3_1_3 VDD VSS / delta3_4

*--- delta3_1 delay chain (2 stages) ---*
XDDELTA3_1 clk n_30 delta3_1_0 delta3_1_1 delta3_1_2 delta3_1_3 tmp_delta3_1_0 tmp_delta3_1_1 tmp_delta3_1_2 tmp_delta3_1_3 VDD VSS / delay1_4_391
XDDELTA3_2 clk n_34 tmp_delta3_1_0 tmp_delta3_1_1 tmp_delta3_1_2 tmp_delta3_1_3 tmp2_delta3_1_0 tmp2_delta3_1_1 tmp2_delta3_1_2 tmp2_delta3_1_3 VDD VSS / delay1_4_390

*--- dadz2 delay (1 stage each) ---*
* DD2_1: in={UNC_Z5,UNC_Z4,dadz2_1[1:0]} out={tmp_dadz2_1[3],UNC12,tmp_dadz2_1[1:0]}
XDD2_1 clk n_5 dadz2_1_0 dadz2_1_1 UNCONNECTED_HIER_Z4 UNCONNECTED_HIER_Z5 tmp_dadz2_1_0 tmp_dadz2_1_1 UNCONNECTED12 tmp_dadz2_1_3 VDD VSS / delay1_4_2
* DD2_2: in={UNC_Z7,UNC_Z6,dadz2_2[1:0]} out={tmp_dadz2_2[3],UNC13,tmp_dadz2_2[1:0]}
XDD2_2 clk n_5 dadz2_2_0 dadz2_2_1 UNCONNECTED_HIER_Z6 UNCONNECTED_HIER_Z7 tmp_dadz2_2_0 tmp_dadz2_2_1 UNCONNECTED13 tmp_dadz2_2_3 VDD VSS / delay1_4_2_396

*--- delta2 computation ---*
* DELTA2_1: dadz={UNC_Z11,UNC_Z10,tmp_dadz2_1[1:0]} w3=tmp2_w3_11 delta3=delta3_1 delta={UNC16,delta2_1[2:0]}
XDELTA2_1 clk n_8
+ tmp_dadz2_1_0 tmp_dadz2_1_1 UNCONNECTED_HIER_Z10 UNCONNECTED_HIER_Z11
+ tmp2_w3_11_0 tmp2_w3_11_1 tmp2_w3_11_2 tmp2_w3_11_3
+ delta3_1_0 delta3_1_1 delta3_1_2 delta3_1_3
+ delta2_1_0 delta2_1_1 delta2_1_2 UNCONNECTED16 VDD VSS / delta2_4

* DELTA2_2: dadz={UNC_Z13,UNC_Z12,tmp_dadz2_2[1:0]} w3=tmp2_w3_21 delta3=delta3_1 delta={UNC17,delta2_2[2:0]}
XDELTA2_2 clk n_35
+ tmp_dadz2_2_0 tmp_dadz2_2_1 UNCONNECTED_HIER_Z12 UNCONNECTED_HIER_Z13
+ tmp2_w3_21_0 tmp2_w3_21_1 tmp2_w3_21_2 tmp2_w3_21_3
+ delta3_1_0 delta3_1_1 delta3_1_2 delta3_1_3
+ delta2_2_0 delta2_2_1 delta2_2_2 UNCONNECTED17 VDD VSS / delta2_4_75

*--- delta2 delay (1 stage each) ---*
* DD2_D1: in={UNC_Z8,delta2_1[2:0]} out={UNC14,tmp_delta2_1[2:0]}
XDD2_D1 clk n_20 delta2_1_0 delta2_1_1 delta2_1_2 UNCONNECTED_HIER_Z8 tmp_delta2_1_0 tmp_delta2_1_1 tmp_delta2_1_2 UNCONNECTED14 VDD VSS / delay1_4_377
* DD2_D2: in={UNC_Z9,delta2_2[2:0]} out={UNC15,tmp_delta2_2[2:0]}
XDD2_D2 clk n_20 delta2_2_0 delta2_2_1 delta2_2_2 UNCONNECTED_HIER_Z9 tmp_delta2_2_0 tmp_delta2_2_1 tmp_delta2_2_2 UNCONNECTED15 VDD VSS / delay1_4_376

*--- dw gradient computation ---*
* DW2_11: err={UNC_Z22,delta2_1[2:0]} inp=tmp3_k1
XDW2_11 clk n_36 delta2_1_0 delta2_1_1 delta2_1_2 UNCONNECTED_HIER_Z22 tmp3_k1_0 tmp3_k1_1 tmp3_k1_2 tmp3_k1_3 dw2_11_0 dw2_11_1 dw2_11_2 dw2_11_3 VDD VSS / dw4_79
* DW2_12: err={UNC_Z23,delta2_1[2:0]} inp=tmp3_k2
XDW2_12 clk n_44 delta2_1_0 delta2_1_1 delta2_1_2 UNCONNECTED_HIER_Z23 tmp3_k2_0 tmp3_k2_1 tmp3_k2_2 tmp3_k2_3 dw2_12_0 dw2_12_1 dw2_12_2 dw2_12_3 VDD VSS / dw4_77
* DW2_21: err={UNC_Z24,delta2_2[2:0]} inp=tmp3_k1
XDW2_21 clk n_31 delta2_2_0 delta2_2_1 delta2_2_2 UNCONNECTED_HIER_Z24 tmp3_k1_0 tmp3_k1_1 tmp3_k1_2 tmp3_k1_3 dw2_21_0 dw2_21_1 dw2_21_2 dw2_21_3 VDD VSS / dw4_78
* DW2_22: err={UNC_Z25,delta2_2[2:0]} inp=tmp3_k2
XDW2_22 clk n_35 delta2_2_0 delta2_2_1 delta2_2_2 UNCONNECTED_HIER_Z25 tmp3_k2_0 tmp3_k2_1 tmp3_k2_2 tmp3_k2_3 dw2_22_0 dw2_22_1 dw2_22_2 dw2_22_3 VDD VSS / dw4_76
* DW3_11: err=tmp_delta3_1 inp=tmp3_a2_1
XDW3_11 clk n_34 tmp_delta3_1_0 tmp_delta3_1_1 tmp_delta3_1_2 tmp_delta3_1_3 tmp3_a2_1_0 tmp3_a2_1_1 tmp3_a2_1_2 tmp3_a2_1_3 dw3_11_0 dw3_11_1 dw3_11_2 dw3_11_3 VDD VSS / dw4
* DW3_21: err=tmp_delta3_1 inp=tmp3_a2_2
XDW3_21 clk n_32 tmp_delta3_1_0 tmp_delta3_1_1 tmp_delta3_1_2 tmp_delta3_1_3 tmp3_a2_2_0 tmp3_a2_2_1 tmp3_a2_2_2 tmp3_a2_2_3 dw3_21_0 dw3_21_1 dw3_21_2 dw3_21_3 VDD VSS / dw4_80

*--- dw_adder (accumulate gradients over 4 samples) ---*
* cap_dw pattern: {cap_dw_X[3],UNC_hi,UNC_hi,cap_dw_X[0]} — bits 1,2 undriven
XDWA2_11 clk n_30 dw2_11_0 dw2_11_1 dw2_11_2 dw2_11_3 cap_dw2_11_0 UNCONNECTED21 UNCONNECTED22 cap_dw2_11_3 VDD VSS / dw_adder4_84
XDWA2_12 clk n_3 dw2_12_0 dw2_12_1 dw2_12_2 dw2_12_3 cap_dw2_12_0 UNCONNECTED23 UNCONNECTED24 cap_dw2_12_3 VDD VSS / dw_adder4_82
XDWA2_21 clk n_28 dw2_21_0 dw2_21_1 dw2_21_2 dw2_21_3 cap_dw2_21_0 UNCONNECTED25 UNCONNECTED26 cap_dw2_21_3 VDD VSS / dw_adder4_83
XDWA2_22 clk n_27 dw2_22_0 dw2_22_1 dw2_22_2 dw2_22_3 cap_dw2_22_0 UNCONNECTED27 UNCONNECTED28 cap_dw2_22_3 VDD VSS / dw_adder4_81
XDWA3_11 clk n_6 dw3_11_0 dw3_11_1 dw3_11_2 dw3_11_3 cap_dw3_11_0 UNCONNECTED29 UNCONNECTED30 cap_dw3_11_3 VDD VSS / dw_adder4
XDWA3_21 clk n_25 dw3_21_0 dw3_21_1 dw3_21_2 dw3_21_3 cap_dw3_21_0 UNCONNECTED31 UNCONNECTED32 cap_dw3_21_3 VDD VSS / dw_adder4_85

*--- db_adder (accumulate bias gradients) ---*
* DBA2_1: delta={UNC_Z2,tmp_delta2_1[2:0]} cap_db={UNC6,UNC5,UNC4,cap_db2_1[0]}
XDBA2_1 clk n_5 tmp_delta2_1_0 tmp_delta2_1_1 tmp_delta2_1_2 UNCONNECTED_HIER_Z2 cap_db2_1_0 UNCONNECTED4 UNCONNECTED5 UNCONNECTED6 VDD VSS / db_adder4_41
* DBA2_2: delta={UNC_Z3,tmp_delta2_2[2:0]} cap_db={UNC9,UNC8,UNC7,cap_db2_2[0]}
XDBA2_2 clk n_5 tmp_delta2_2_0 tmp_delta2_2_1 tmp_delta2_2_2 UNCONNECTED_HIER_Z3 cap_db2_2_0 UNCONNECTED7 UNCONNECTED8 UNCONNECTED9 VDD VSS / db_adder4_40
* DBA3_1: delta=tmp2_delta3_1 cap_db={cap_db3_1[3],UNC11,UNC10,cap_db3_1[0]}
XDBA3_1 clk n_38 tmp2_delta3_1_0 tmp2_delta3_1_1 tmp2_delta3_1_2 tmp2_delta3_1_3 cap_db3_1_0 UNCONNECTED10 UNCONNECTED11 cap_db3_1_3 VDD VSS / db_adder4

.ENDS backward4

* End backward4.cdl
* Total modules: 46 (24 delay + 3 dadz + 2 delta2 + 1 delta3 + 6 dw4 + 6 dw_adder + 3 db_adder + 1 backward4)
