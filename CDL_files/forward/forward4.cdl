*******************************************************************************
* forward4.cdl — All sub-modules + forward4 top
* Syntax: mem4_slim.cdl working reference (/ CELLNAME style)
* Ref libs needed on import: gpdk090, your stdcel lib (has mem4)
*******************************************************************************
*******************************************************************************
* STD CELL STUBS — real transistor layouts exist in your stdcel lib
*******************************************************************************
.SUBCKT INVX1 A Y VDD VSS
*.PININFO A:I Y:O VDD:I VSS:I
.ENDS INVX1

.SUBCKT NAND2X1 A B Y VDD VSS
*.PININFO A:I B:I Y:O VDD:I VSS:I
.ENDS NAND2X1

.SUBCKT NOR2X1 A B Y VDD VSS
*.PININFO A:I B:I Y:O VDD:I VSS:I
.ENDS NOR2X1

.SUBCKT XNOR2X1 A B Y VDD VSS
*.PININFO A:I B:I Y:O VDD:I VSS:I
.ENDS XNOR2X1

.SUBCKT DFFQX1 CK D Q VDD VSS
*.PININFO CK:I D:I Q:O VDD:I VSS:I
.ENDS DFFQX1

*******************************************************************************
* DERIVED CELL WRAPPERS — built from stubs above
*******************************************************************************

* AND2X1 = NAND2 + INV
.SUBCKT AND2X1 A B Y VDD VSS
XNAND1 A B n_ab VDD VSS / NAND2X1
XINV1 n_ab Y VDD VSS / INVX1
.ENDS AND2X1

* OR2X1 = NOR2 + INV
.SUBCKT OR2X1 A B Y VDD VSS
XNOR1 A B n_ab VDD VSS / NOR2X1
XINV1 n_ab Y VDD VSS / INVX1
.ENDS OR2X1

* XOR2X1 = XNOR2 + INV
.SUBCKT XOR2X1 A B Y VDD VSS
XXNOR1 A B n_ab VDD VSS / XNOR2X1
XINV1 n_ab Y VDD VSS / INVX1
.ENDS XOR2X1

* MX2X1: Y=A when S0=0, Y=B when S0=1
* Standard NAND-NAND-NAND-INV mux
* Y = NAND( NAND(A,~S0), NAND(B,S0) )
.SUBCKT MX2X1 A B S0 Y VDD VSS
XINV_S0 S0 S0b VDD VSS / INVX1
XNA A S0b na VDD VSS / NAND2X1
XNB B S0 nb VDD VSS / NAND2X1
XOUT na nb Y VDD VSS / NAND2X1
.ENDS MX2X1

*******************************************************************************
* MAPPING WRAPPERS — clock variants + scan DFF
*******************************************************************************

* CLKINVX1 = INVX1
.SUBCKT CLKINVX1 A Y VDD VSS
XINV1 A Y VDD VSS / INVX1
.ENDS CLKINVX1

* CLKXOR2X1 = XOR2X1 (which = XNOR2X1 + INVX1)
.SUBCKT CLKXOR2X1 A B Y VDD VSS
XXOR1 A B Y VDD VSS / XOR2X1
.ENDS CLKXOR2X1

* SDFFQX1: SE=0→Q=D, SE=1→Q=SI
.SUBCKT SDFFQX1 CK D SI SE Q VDD VSS
XMUX1 D SI SE net_mux VDD VSS / MX2X1
XDFF1 CK net_mux Q VDD VSS / DFFQX1
.ENDS SDFFQX1

*******************************************************************************
* mem4 STUB (real schematic in stdcel lib)
*******************************************************************************
.SUBCKT mem4 CLK DIN ADDR3 ADDR2 ADDR1 ADDR0 DOUT3 DOUT2 DOUT1 DOUT0 VDD VSS
*.PININFO CLK:I DIN:I ADDR3:I ADDR2:I ADDR1:I ADDR0:I
*.PININFO DOUT3:O DOUT2:O DOUT1:O DOUT0:O VDD:I VSS:I
.ENDS mem4

*******************************************************************************
* MODULE: k1_rom4
* Ports: clk din addr[3:0] k_out[3:0]
* Only k_out[2:1] driven (others float)
*******************************************************************************
.SUBCKT k1_rom4 clk din addr_0 addr_1 addr_2 addr_3 k_out_0 k_out_1 k_out_2 k_out_3 VDD VSS
*.PININFO clk:I din:I addr_0:I addr_1:I addr_2:I addr_3:I
*.PININFO k_out_0:O k_out_1:O k_out_2:O k_out_3:O VDD:I VSS:I

Xk_out_reg_1 clk n_3 k_out_1 VDD VSS / DFFQX1
Xk_out_reg_2 clk n_1 k_out_2 VDD VSS / DFFQX1
Xg37 n_2 addr_1 n_3 VDD VSS / NOR2X1
Xg38 n_1 n_2 VDD VSS / CLKINVX1
Xg39 addr_2 addr_3 n_1 VDD VSS / NOR2X1

.ENDS k1_rom4

*******************************************************************************
* MODULE: k2_rom4
*******************************************************************************
.SUBCKT k2_rom4 clk din addr_0 addr_1 addr_2 addr_3 k_out_0 k_out_1 k_out_2 k_out_3 VDD VSS
*.PININFO clk:I din:I addr_0:I addr_1:I addr_2:I addr_3:I
*.PININFO k_out_0:O k_out_1:O k_out_2:O k_out_3:O VDD:I VSS:I

Xk_out_reg_1 clk n_3 k_out_1 VDD VSS / DFFQX1
Xk_out_reg_2 clk n_1 k_out_2 VDD VSS / DFFQX1
Xg37 n_2 addr_0 n_3 VDD VSS / NOR2X1
Xg38 n_1 n_2 VDD VSS / CLKINVX1
Xg39 addr_2 addr_3 n_1 VDD VSS / NOR2X1

.ENDS k2_rom4

*******************************************************************************
* MODULE: t1_rom4
* Note: register index [0] outputs to t_out[2] (Genus remap)
*******************************************************************************
.SUBCKT t1_rom4 clk din addr_0 addr_1 addr_2 addr_3 t_out_0 t_out_1 t_out_2 t_out_3 VDD VSS
*.PININFO clk:I din:I addr_0:I addr_1:I addr_2:I addr_3:I
*.PININFO t_out_0:O t_out_1:O t_out_2:O t_out_3:O VDD:I VSS:I

Xt_out_reg_0 clk n_3 t_out_2 VDD VSS / DFFQX1
Xg30 n_1 n_2 n_3 VDD VSS / AND2X1
Xg31 addr_2 addr_1 n_2 VDD VSS / NOR2X1
Xg32 addr_3 addr_0 n_1 VDD VSS / NOR2X1

.ENDS t1_rom4

*******************************************************************************
* MODULE: counter4
* finish_updating port has no driver (Genus removed Nupdate counter)
*******************************************************************************
.SUBCKT counter4 clk reset out_0 out_1 out_2 out_3 finish_updating VDD VSS
*.PININFO clk:I reset:I out_0:O out_1:O out_2:O out_3:O finish_updating:O VDD:I VSS:I

Xout_reg_0 clk n_15 out_0 VDD VSS / DFFQX1
Xout_reg_1 clk n_12 out_1 VDD VSS / DFFQX1
Xout_reg_2 clk n_14 out_2 VDD VSS / DFFQX1
Xout_reg_3 clk n_13 out_3 VDD VSS / DFFQX1
Xg226 out_0 n_11 n_15 VDD VSS / NOR2X1
Xg227 n_7 n_10 n_14 VDD VSS / AND2X1
Xg228 n_9 n_11 n_13 VDD VSS / NOR2X1
Xg229 n_0 n_11 n_12 VDD VSS / NOR2X1
Xg230 n_10 n_11 VDD VSS / CLKINVX1
Xg231 n_8 reset n_10 VDD VSS / NOR2X1
Xg232 out_3 n_5 n_9 VDD VSS / CLKXOR2X1
Xg233 n_19 out_0 n_8 VDD VSS / NOR2X1
Xg234 out_2 n_3 n_7 VDD VSS / XNOR2X1
Xg237 n_2 n_3 n_5 VDD VSS / OR2X1
Xg239 out_1 out_0 n_3 VDD VSS / NAND2X1
Xg241 out_2 n_2 VDD VSS / CLKINVX1
Xg2 out_0 out_1 n_0 VDD VSS / XNOR2X1
Xg244 n_18 out_1 n_19 VDD VSS / OR2X1
Xg3 out_3 out_2 n_18 VDD VSS / NAND2X1

.ENDS counter4

*******************************************************************************
* MODULE: selector4
*******************************************************************************
.SUBCKT selector4 clk reset update_coeff enable_update VDD VSS
*.PININFO clk:I reset:I update_coeff:I enable_update:O VDD:I VSS:I

Xenable_update_reg clk n_16 enable_update VDD VSS / DFFQX1
Xg177 n_15 reset n_16 VDD VSS / NOR2X1
Xg178 n_14 update_coeff n_15 VDD VSS / NAND2X1
Xg180 n_12 n_13 n_14 VDD VSS / NOR2X1
Xg181 cnt_3 cnt_2 n_13 VDD VSS / NAND2X1
Xg182 cnt_1 cnt_0 n_12 VDD VSS / OR2X1
Xcnt_reg_0 clk n_5 cnt_0 VDD VSS / DFFQX1
Xcnt_reg_1 clk n_8 cnt_1 VDD VSS / DFFQX1
Xcnt_reg_2 clk n_10 cnt_2 VDD VSS / DFFQX1
Xcnt_reg_3 clk n_11 cnt_3 VDD VSS / DFFQX1
Xg224 n_9 n_21 n_11 VDD VSS / NOR2X1
Xg226 n_7 n_21 n_10 VDD VSS / NOR2X1
Xg227 cnt_3 n_6 n_9 VDD VSS / CLKXOR2X1
Xg229 n_4 n_21 n_8 VDD VSS / NOR2X1
Xg230 cnt_2 n_1 n_7 VDD VSS / CLKXOR2X1
Xg231 n_2 cnt_2 n_6 VDD VSS / NAND2X1
Xg232 cnt_0 n_21 n_5 VDD VSS / NOR2X1
Xg233 cnt_0 cnt_1 n_4 VDD VSS / XNOR2X1
Xg235 n_1 n_2 VDD VSS / CLKINVX1
Xg236 cnt_1 cnt_0 n_1 VDD VSS / NAND2X1
Xg2 n_14 reset n_21 VDD VSS / OR2X1

.ENDS selector4

*******************************************************************************
* MODULE: sel_k4
*******************************************************************************
.SUBCKT sel_k4 kin_0 kin_1 kin_2 kin_3 krom_0 krom_1 krom_2 krom_3 upd k_0 k_1 k_2 k_3 VDD VSS

Xg59 kin_2 krom_2 upd k_2 VDD VSS / MX2X1
Xg60 kin_1 krom_1 upd k_1 VDD VSS / MX2X1
Xg61 n_0 kin_3 k_3 VDD VSS / AND2X1
Xg62 n_0 kin_0 k_0 VDD VSS / AND2X1
Xg63 upd n_0 VDD VSS / CLKINVX1

.ENDS sel_k4

*******************************************************************************
* MODULE: sel_k4_86  (identical structure to sel_k4)
*******************************************************************************
.SUBCKT sel_k4_86 kin_0 kin_1 kin_2 kin_3 krom_0 krom_1 krom_2 krom_3 upd k_0 k_1 k_2 k_3 VDD VSS

Xg59 kin_2 krom_2 upd k_2 VDD VSS / MX2X1
Xg60 kin_1 krom_1 upd k_1 VDD VSS / MX2X1
Xg61 n_0 kin_3 k_3 VDD VSS / AND2X1
Xg62 n_0 kin_0 k_0 VDD VSS / AND2X1
Xg63 upd n_0 VDD VSS / CLKINVX1

.ENDS sel_k4_86

*******************************************************************************
* MODULE: b_reg4_INITn8  (bias reg, init=-8, uses SDFFQX1+XOR2X1)
*******************************************************************************
.SUBCKT b_reg4_INITn8 clk reset sel_i sel_u db_0 db_1 db_2 db_3 b_0 b_1 b_2 b_3 VDD VSS

Xb_reg_3 clk n_1 n_13 n_3 b_3 VDD VSS / SDFFQX1
Xb_reg_2 clk n_14 b_2 VDD VSS / DFFQX1
Xb_reg_1 clk n_12 b_1 VDD VSS / DFFQX1
Xb_reg_0 clk n_10 b_0 VDD VSS / DFFQX1
Xg186 n_0 n_3 n_14 VDD VSS / AND2X1
Xg187 b_3 n_11 n_13 VDD VSS / XNOR2X1
Xg189 n_9 n_3 n_12 VDD VSS / AND2X1
Xg191 n_8 b_2 n_11 VDD VSS / NAND2X1
Xg192 n_7 n_3 n_10 VDD VSS / AND2X1
Xg193 b_1 n_6 n_9 VDD VSS / XNOR2X1
Xg195 n_6 n_2 n_8 VDD VSS / NOR2X1
Xg196 n_4 b_0 n_7 VDD VSS / XNOR2X1
Xg197 b_0 n_5 n_6 VDD VSS / NAND2X1
Xg198 n_4 n_5 VDD VSS / CLKINVX1
Xg199 sel_u db_0 n_4 VDD VSS / NAND2X1
Xg200 reset sel_i n_3 VDD VSS / NOR2X1
Xg201 b_1 n_2 VDD VSS / CLKINVX1
Xg202 reset n_1 VDD VSS / CLKINVX1
Xg2 b_2 n_8 n_0 VDD VSS / XOR2X1

.ENDS b_reg4_INITn8

*******************************************************************************
* MODULE: b_reg4_INITn8_37  (identical structure to b_reg4_INITn8)
*******************************************************************************
.SUBCKT b_reg4_INITn8_37 clk reset sel_i sel_u db_0 db_1 db_2 db_3 b_0 b_1 b_2 b_3 VDD VSS

Xb_reg_3 clk n_1 n_13 n_3 b_3 VDD VSS / SDFFQX1
Xb_reg_2 clk n_14 b_2 VDD VSS / DFFQX1
Xb_reg_1 clk n_12 b_1 VDD VSS / DFFQX1
Xb_reg_0 clk n_10 b_0 VDD VSS / DFFQX1
Xg186 n_0 n_3 n_14 VDD VSS / AND2X1
Xg187 b_3 n_11 n_13 VDD VSS / XNOR2X1
Xg189 n_9 n_3 n_12 VDD VSS / AND2X1
Xg191 n_8 b_2 n_11 VDD VSS / NAND2X1
Xg192 n_7 n_3 n_10 VDD VSS / AND2X1
Xg193 b_1 n_6 n_9 VDD VSS / XNOR2X1
Xg195 n_6 n_2 n_8 VDD VSS / NOR2X1
Xg196 n_4 b_0 n_7 VDD VSS / XNOR2X1
Xg197 b_0 n_5 n_6 VDD VSS / NAND2X1
Xg198 n_4 n_5 VDD VSS / CLKINVX1
Xg199 sel_u db_0 n_4 VDD VSS / NAND2X1
Xg200 reset sel_i n_3 VDD VSS / NOR2X1
Xg201 b_1 n_2 VDD VSS / CLKINVX1
Xg202 reset n_1 VDD VSS / CLKINVX1
Xg2 b_2 n_8 n_0 VDD VSS / XOR2X1

.ENDS b_reg4_INITn8_37

*******************************************************************************
* MODULE: b_reg4_INITn8_36  (different structure: CLKXOR2X1, MX2X1, 2 NAND2)
*******************************************************************************
.SUBCKT b_reg4_INITn8_36 clk reset sel_i sel_u db_0 db_1 db_2 db_3 b_0 b_1 b_2 b_3 VDD VSS

Xb_reg_3 clk n_0 n_24 n_5 b_3 VDD VSS / SDFFQX1
Xb_reg_2 clk n_23 b_2 VDD VSS / DFFQX1
Xb_reg_1 clk n_21 b_1 VDD VSS / DFFQX1
Xb_reg_0 clk n_16 b_0 VDD VSS / DFFQX1
Xg277 n_11 n_22 n_24 VDD VSS / XNOR2X1
Xg279 n_20 n_5 n_23 VDD VSS / AND2X1
Xg280 n_19 n_8 n_22 VDD VSS / NOR2X1
Xg281 n_18 n_5 n_21 VDD VSS / AND2X1
Xg282 n_14 n_17 n_20 VDD VSS / CLKXOR2X1
Xg284 n_17 n_10 n_19 VDD VSS / NOR2X1
Xg285 n_9 n_12 n_18 VDD VSS / CLKXOR2X1
Xg286 n_15 n_7 n_17 VDD VSS / NOR2X1
Xg287 n_13 n_5 n_16 VDD VSS / AND2X1
Xg288 n_6 n_9 n_15 VDD VSS / NOR2X1
Xg289 n_10 n_8 n_14 VDD VSS / OR2X1
Xg290 n_3 b_0 n_13 VDD VSS / XNOR2X1
Xg291 n_6 n_7 n_12 VDD VSS / OR2X1
Xg292 n_2 n_1 b_3 n_11 VDD VSS / MX2X1
Xg293 b_2 n_2 n_10 VDD VSS / NOR2X1
Xg294 b_0 n_4 n_9 VDD VSS / NAND2X1
Xg295 b_2 n_2 n_8 VDD VSS / AND2X1
Xg296 b_1 n_2 n_7 VDD VSS / AND2X1
Xg297 b_1 n_2 n_6 VDD VSS / NOR2X1
Xg298 reset sel_i n_5 VDD VSS / NOR2X1
Xg299 n_3 n_4 VDD VSS / CLKINVX1
Xg300 n_1 n_2 VDD VSS / CLKINVX1
Xg301 sel_u db_0 n_3 VDD VSS / NAND2X1
Xg302 sel_u db_1 n_1 VDD VSS / NAND2X1
Xg303 reset n_0 VDD VSS / CLKINVX1

.ENDS b_reg4_INITn8_36

*******************************************************************************
* MODULE: w_reg4_INIT1  (w2_11: init=1=0.125 Q1.3)
*******************************************************************************
.SUBCKT w_reg4_INIT1 clk reset sel_i sel_u dw_0 dw_1 dw_2 dw_3 w_0 w_1 w_2 w_3 VDD VSS

Xw_reg_3 clk n_25 w_3 VDD VSS / DFFQX1
Xw_reg_2 clk n_23 w_2 VDD VSS / DFFQX1
Xw_reg_1 clk n_21 w_1 VDD VSS / DFFQX1
Xw_reg_0 clk n_14 n_0 n_4 w_0 VDD VSS / SDFFQX1
Xg283 n_24 n_4 n_25 VDD VSS / NOR2X1
Xg285 n_12 n_22 n_24 VDD VSS / XNOR2X1
Xg287 n_20 n_4 n_23 VDD VSS / NOR2X1
Xg288 n_19 n_8 n_22 VDD VSS / NAND2X1
Xg290 n_18 n_4 n_21 VDD VSS / NOR2X1
Xg291 n_15 n_17 n_20 VDD VSS / XNOR2X1
Xg292 n_17 n_11 n_19 VDD VSS / NAND2X1
Xg293 n_10 n_13 n_18 VDD VSS / XNOR2X1
Xg294 n_16 n_5 n_17 VDD VSS / NAND2X1
Xg295 n_10 n_6 n_16 VDD VSS / OR2X1
Xg296 n_11 n_8 n_15 VDD VSS / AND2X1
Xg297 n_9 n_10 n_14 VDD VSS / AND2X1
Xg298 n_7 n_5 n_13 VDD VSS / NAND2X1
Xg299 n_2 n_1 w_3 n_12 VDD VSS / MX2X1
Xg300 n_3 w_0 n_9 VDD VSS / OR2X1
Xg301 n_2 w_2 n_11 VDD VSS / OR2X1
Xg302 w_0 n_3 n_10 VDD VSS / NAND2X1
Xg303 n_6 n_7 VDD VSS / CLKINVX1
Xg304 w_2 n_2 n_8 VDD VSS / NAND2X1
Xg305 w_1 n_2 n_6 VDD VSS / NOR2X1
Xg306 w_1 n_2 n_5 VDD VSS / NAND2X1
Xg307 sel_i reset n_4 VDD VSS / OR2X1
Xg308 n_1 n_2 VDD VSS / CLKINVX1
Xg309 sel_u dw_0 n_3 VDD VSS / AND2X1
Xg310 sel_u dw_1 n_1 VDD VSS / NAND2X1
Xg311 reset n_0 VDD VSS / CLKINVX1

.ENDS w_reg4_INIT1

*******************************************************************************
* MODULE: w_reg4_INIT2  (w2_12: init=2=0.25)
*******************************************************************************
.SUBCKT w_reg4_INIT2 clk reset sel_i sel_u dw_0 dw_1 dw_2 dw_3 w_0 w_1 w_2 w_3 VDD VSS

Xw_reg_3 clk n_25 w_3 VDD VSS / DFFQX1
Xw_reg_2 clk n_23 w_2 VDD VSS / DFFQX1
Xw_reg_1 clk n_19 n_0 n_5 w_1 VDD VSS / SDFFQX1
Xw_reg_0 clk n_17 w_0 VDD VSS / DFFQX1
Xg285 n_24 n_5 n_25 VDD VSS / NOR2X1
Xg287 n_12 n_22 n_24 VDD VSS / XNOR2X1
Xg289 n_21 n_5 n_23 VDD VSS / NOR2X1
Xg290 n_20 n_9 n_22 VDD VSS / NAND2X1
Xg291 n_15 n_18 n_21 VDD VSS / XNOR2X1
Xg293 n_18 n_11 n_20 VDD VSS / NAND2X1
Xg294 n_10 n_13 n_19 VDD VSS / CLKXOR2X1
Xg295 n_16 n_6 n_18 VDD VSS / NAND2X1
Xg296 n_14 n_5 n_17 VDD VSS / NOR2X1
Xg297 n_10 n_7 n_16 VDD VSS / OR2X1
Xg298 n_11 n_9 n_15 VDD VSS / AND2X1
Xg299 n_3 w_0 n_14 VDD VSS / CLKXOR2X1
Xg300 n_8 n_6 n_13 VDD VSS / NAND2X1
Xg301 n_2 n_1 w_3 n_12 VDD VSS / MX2X1
Xg302 n_2 w_2 n_11 VDD VSS / OR2X1
Xg303 w_0 n_4 n_10 VDD VSS / NAND2X1
Xg304 n_7 n_8 VDD VSS / CLKINVX1
Xg305 w_2 n_2 n_9 VDD VSS / NAND2X1
Xg306 w_1 n_2 n_7 VDD VSS / NOR2X1
Xg307 w_1 n_2 n_6 VDD VSS / NAND2X1
Xg308 sel_i reset n_5 VDD VSS / OR2X1
Xg309 n_3 n_4 VDD VSS / CLKINVX1
Xg310 n_1 n_2 VDD VSS / CLKINVX1
Xg311 sel_u dw_0 n_3 VDD VSS / NAND2X1
Xg312 sel_u dw_1 n_1 VDD VSS / NAND2X1
Xg313 reset n_0 VDD VSS / CLKINVX1

.ENDS w_reg4_INIT2

*******************************************************************************
* MODULE: w_reg4_INIT3  (w2_21: init=3=0.375)
*******************************************************************************
.SUBCKT w_reg4_INIT3 clk reset sel_i sel_u dw_0 dw_1 dw_2 dw_3 w_0 w_1 w_2 w_3 VDD VSS

Xw_reg_3 clk n_24 w_3 VDD VSS / DFFQX1
Xw_reg_2 clk n_22 w_2 VDD VSS / DFFQX1
Xw_reg_1 clk n_18 n_0 n_5 w_1 VDD VSS / SDFFQX1
Xw_reg_0 clk n_14 n_0 n_5 w_0 VDD VSS / SDFFQX1
Xg315 n_23 n_5 n_24 VDD VSS / NOR2X1
Xg317 n_12 n_20 n_23 VDD VSS / XNOR2X1
Xg319 n_21 n_5 n_22 VDD VSS / NOR2X1
Xg321 n_15 n_17 n_21 VDD VSS / XNOR2X1
Xg322 n_19 n_11 n_20 VDD VSS / NAND2X1
Xg323 n_17 n_9 n_19 VDD VSS / NAND2X1
Xg324 n_10 n_13 n_18 VDD VSS / CLKXOR2X1
Xg325 n_16 n_6 n_17 VDD VSS / NAND2X1
Xg326 n_10 n_7 n_16 VDD VSS / OR2X1
Xg327 n_9 n_11 n_15 VDD VSS / AND2X1
Xg328 n_3 w_0 n_14 VDD VSS / XNOR2X1
Xg329 n_8 n_6 n_13 VDD VSS / NAND2X1
Xg330 n_2 n_1 w_3 n_12 VDD VSS / MX2X1
Xg331 w_2 n_2 n_11 VDD VSS / NAND2X1
Xg332 w_0 n_4 n_10 VDD VSS / NAND2X1
Xg333 n_7 n_8 VDD VSS / CLKINVX1
Xg334 n_2 w_2 n_9 VDD VSS / OR2X1
Xg335 w_1 n_2 n_7 VDD VSS / NOR2X1
Xg336 w_1 n_2 n_6 VDD VSS / NAND2X1
Xg337 sel_i reset n_5 VDD VSS / OR2X1
Xg338 n_3 n_4 VDD VSS / CLKINVX1
Xg339 n_1 n_2 VDD VSS / CLKINVX1
Xg340 sel_u dw_0 n_3 VDD VSS / NAND2X1
Xg341 sel_u dw_1 n_1 VDD VSS / NAND2X1
Xg342 reset n_0 VDD VSS / CLKINVX1

.ENDS w_reg4_INIT3

*******************************************************************************
* MODULE: w_reg4_INIT4  (w2_22: init=4=0.5, SDFFQX1 on w[2])
*******************************************************************************
.SUBCKT w_reg4_INIT4 clk reset sel_i sel_u dw_0 dw_1 dw_2 dw_3 w_0 w_1 w_2 w_3 VDD VSS

Xw_reg_3 clk n_24 w_3 VDD VSS / DFFQX1
Xw_reg_2 clk n_0 n_20 n_3 w_2 VDD VSS / SDFFQX1
Xw_reg_1 clk n_21 w_1 VDD VSS / DFFQX1
Xw_reg_0 clk n_16 w_0 VDD VSS / DFFQX1
Xg282 n_23 n_3 n_24 VDD VSS / AND2X1
Xg283 n_11 n_22 n_23 VDD VSS / XNOR2X1
Xg285 n_19 n_8 n_22 VDD VSS / NOR2X1
Xg286 n_18 n_3 n_21 VDD VSS / AND2X1
Xg287 n_14 n_17 n_20 VDD VSS / XNOR2X1
Xg289 n_17 n_10 n_19 VDD VSS / NOR2X1
Xg290 n_9 n_12 n_18 VDD VSS / CLKXOR2X1
Xg291 n_15 n_7 n_17 VDD VSS / NOR2X1
Xg292 n_13 n_3 n_16 VDD VSS / AND2X1
Xg293 n_6 n_9 n_15 VDD VSS / NOR2X1
Xg294 n_10 n_8 n_14 VDD VSS / NOR2X1
Xg295 n_4 w_0 n_13 VDD VSS / XNOR2X1
Xg296 n_6 n_7 n_12 VDD VSS / OR2X1
Xg297 n_2 n_1 w_3 n_11 VDD VSS / MX2X1
Xg298 w_2 n_2 n_10 VDD VSS / NOR2X1
Xg299 w_0 n_5 n_9 VDD VSS / NAND2X1
Xg300 w_2 n_2 n_8 VDD VSS / AND2X1
Xg301 w_1 n_2 n_7 VDD VSS / AND2X1
Xg302 w_1 n_2 n_6 VDD VSS / NOR2X1
Xg303 n_4 n_5 VDD VSS / CLKINVX1
Xg304 sel_u dw_0 n_4 VDD VSS / NAND2X1
Xg305 n_1 n_2 VDD VSS / CLKINVX1
Xg306 reset sel_i n_3 VDD VSS / NOR2X1
Xg307 sel_u dw_1 n_1 VDD VSS / NAND2X1
Xg308 reset n_0 VDD VSS / CLKINVX1

.ENDS w_reg4_INIT4

*******************************************************************************
* MODULE: w_reg4_INIT5  (w3_11: init=5=0.625, 2 SDFFQX1)
*******************************************************************************
.SUBCKT w_reg4_INIT5 clk reset sel_i sel_u dw_0 dw_1 dw_2 dw_3 w_0 w_1 w_2 w_3 VDD VSS

Xw_reg_3 clk n_23 w_3 VDD VSS / DFFQX1
Xw_reg_2 clk n_0 n_19 n_3 w_2 VDD VSS / SDFFQX1
Xw_reg_1 clk n_20 w_1 VDD VSS / DFFQX1
Xw_reg_0 clk n_0 n_13 n_3 w_0 VDD VSS / SDFFQX1
Xg315 n_22 n_3 n_23 VDD VSS / AND2X1
Xg316 n_11 n_21 n_22 VDD VSS / XNOR2X1
Xg318 n_18 n_10 n_21 VDD VSS / NOR2X1
Xg320 n_17 n_3 n_20 VDD VSS / AND2X1
Xg321 n_14 n_16 n_19 VDD VSS / XNOR2X1
Xg322 n_16 n_8 n_18 VDD VSS / NOR2X1
Xg323 n_9 n_12 n_17 VDD VSS / CLKXOR2X1
Xg324 n_15 n_6 n_16 VDD VSS / NOR2X1
Xg325 n_7 n_9 n_15 VDD VSS / NOR2X1
Xg326 n_8 n_10 n_14 VDD VSS / NOR2X1
Xg327 n_4 w_0 n_13 VDD VSS / XNOR2X1
Xg328 n_7 n_6 n_12 VDD VSS / OR2X1
Xg329 n_2 n_1 w_3 n_11 VDD VSS / MX2X1
Xg330 w_2 n_2 n_10 VDD VSS / AND2X1
Xg331 w_0 n_5 n_9 VDD VSS / NAND2X1
Xg332 w_2 n_2 n_8 VDD VSS / NOR2X1
Xg333 w_1 n_2 n_7 VDD VSS / NOR2X1
Xg334 w_1 n_2 n_6 VDD VSS / AND2X1
Xg335 n_4 n_5 VDD VSS / CLKINVX1
Xg336 sel_u dw_0 n_4 VDD VSS / NAND2X1
Xg337 n_1 n_2 VDD VSS / CLKINVX1
Xg338 reset sel_i n_3 VDD VSS / NOR2X1
Xg339 sel_u dw_1 n_1 VDD VSS / NAND2X1
Xg340 reset n_0 VDD VSS / CLKINVX1

.ENDS w_reg4_INIT5

*******************************************************************************
* MODULE: w_reg4_INIT7  (w3_21: init=7=0.875, CLKXOR2X1 style)
*******************************************************************************
.SUBCKT w_reg4_INIT7 clk reset sel_i sel_u dw_0 dw_1 dw_2 dw_3 w_0 w_1 w_2 w_3 VDD VSS

Xw_reg_3 clk n_30 w_3 VDD VSS / DFFQX1
Xw_reg_2 clk n_29 w_2 VDD VSS / DFFQX1
Xw_reg_1 clk n_27 w_1 VDD VSS / DFFQX1
Xw_reg_0 clk n_22 w_0 VDD VSS / DFFQX1
Xg355 n_28 n_3 n_30 VDD VSS / NOR2X1
Xg357 n_6 n_26 n_29 VDD VSS / NAND2X1
Xg358 n_13 n_25 n_28 VDD VSS / XNOR2X1
Xg359 n_6 n_24 n_27 VDD VSS / NAND2X1
Xg360 n_3 n_23 n_26 VDD VSS / OR2X1
Xg361 n_21 n_11 n_25 VDD VSS / NAND2X1
Xg363 n_3 n_20 n_24 VDD VSS / OR2X1
Xg364 n_16 n_19 n_23 VDD VSS / XNOR2X1
Xg365 n_6 n_18 n_22 VDD VSS / NAND2X1
Xg366 n_19 n_12 n_21 VDD VSS / NAND2X1
Xg367 n_10 n_14 n_20 VDD VSS / XNOR2X1
Xg368 n_17 n_7 n_19 VDD VSS / NAND2X1
Xg369 n_3 n_15 n_18 VDD VSS / OR2X1
Xg370 n_10 n_8 n_17 VDD VSS / OR2X1
Xg371 n_12 n_11 n_16 VDD VSS / AND2X1
Xg372 n_4 w_0 n_15 VDD VSS / CLKXOR2X1
Xg373 n_9 n_7 n_14 VDD VSS / NAND2X1
Xg374 n_1 n_0 w_3 n_13 VDD VSS / MX2X1
Xg375 n_1 w_2 n_12 VDD VSS / OR2X1
Xg376 w_2 n_1 n_11 VDD VSS / NAND2X1
Xg377 w_0 n_5 n_10 VDD VSS / NAND2X1
Xg378 n_8 n_9 VDD VSS / CLKINVX1
Xg379 w_1 n_1 n_8 VDD VSS / NOR2X1
Xg380 w_1 n_1 n_7 VDD VSS / NAND2X1
Xg381 reset n_2 n_6 VDD VSS / OR2X1
Xg382 n_4 n_5 VDD VSS / CLKINVX1
Xg383 sel_u dw_0 n_4 VDD VSS / NAND2X1
Xg384 n_2 n_3 VDD VSS / CLKINVX1
Xg385 n_0 n_1 VDD VSS / CLKINVX1
Xg386 reset sel_i n_2 VDD VSS / NOR2X1
Xg387 sel_u dw_1 n_0 VDD VSS / NAND2X1

.ENDS w_reg4_INIT7

*******************************************************************************
* MODULE: z2_4  (MAC unit: z = x1*w1 + x2*w2 + b, saturated, registered)
* 4-bit Q1.3, used for Z2_1 (hidden neuron 1)
*******************************************************************************
.SUBCKT z2_4 clk reset x1_0 x1_1 x1_2 x1_3 x2_0 x2_1 x2_2 x2_3 w1_0 w1_1 w1_2 w1_3 w2_0 w2_1 w2_2 w2_3 b_0 b_1 b_2 b_3 z_0 z_1 z_2 z_3 VDD VSS

Xz_reg_0 clk n_190 z_0 VDD VSS / DFFQX1
Xz_reg_1 clk n_192 z_1 VDD VSS / DFFQX1
Xz_reg_2 clk n_191 z_2 VDD VSS / DFFQX1
Xz_reg_3 clk n_183 z_3 VDD VSS / DFFQX1
Xg2199 n_187 n_189 n_192 VDD VSS / NOR2X1
Xg2200 n_186 n_189 n_191 VDD VSS / NOR2X1
Xg2201 n_188 n_189 n_190 VDD VSS / NOR2X1
Xg2202 n_185 n_143 n_188 VDD VSS / NOR2X1
Xg2203 reset n_184 n_189 VDD VSS / OR2X1
Xg2204 n_185 n_164 n_187 VDD VSS / NOR2X1
Xg2205 n_185 n_173 n_186 VDD VSS / NOR2X1
Xg2207 n_181 n_179 n_184 VDD VSS / AND2X1
Xg2208 n_179 n_182 n_185 VDD VSS / NOR2X1
Xg2209 n_180 reset n_183 VDD VSS / NOR2X1
Xg2210 n_178 n_176 n_182 VDD VSS / NOR2X1
Xg2211 n_178 n_176 n_181 VDD VSS / NAND2X1
Xg2212 n_179 n_180 VDD VSS / CLKINVX1
Xg2213 n_177 n_167 n_179 VDD VSS / NOR2X1
Xg2214 n_170 n_175 n_178 VDD VSS / CLKXOR2X1
Xg2215 n_175 n_168 n_177 VDD VSS / NOR2X1
Xg2216 n_171 n_172 n_176 VDD VSS / CLKXOR2X1
Xg2217 n_174 n_2 n_175 VDD VSS / NOR2X1
Xg2218 n_169 n_171 n_174 VDD VSS / NOR2X1
Xg2219 n_153 n_163 n_173 VDD VSS / CLKXOR2X1
Xg2220 n_169 n_2 n_172 VDD VSS / OR2X1
Xg2221 n_167 n_168 n_170 VDD VSS / OR2X1
Xg2222 n_166 n_1 n_171 VDD VSS / NOR2X1
Xg2224 n_165 n_154 n_169 VDD VSS / NOR2X1
Xg2225 n_161 n_153 n_166 VDD VSS / NOR2X1
Xg2226 n_162 b_3 n_168 VDD VSS / AND2X1
Xg2227 n_162 b_3 n_167 VDD VSS / NOR2X1
Xg2229 n_137 n_159 n_164 VDD VSS / CLKXOR2X1
Xg2230 n_161 n_1 n_163 VDD VSS / OR2X1
Xg2231 b_3 n_3 n_157 n_165 VDD VSS / MX2X1
Xg2232 n_160 n_156 n_162 VDD VSS / NOR2X1
Xg2234 n_158 n_145 n_161 VDD VSS / NOR2X1
Xg2235 n_155 n_150 n_160 VDD VSS / NOR2X1
Xg2236 n_126 n_149 n_159 VDD VSS / XNOR2X1
Xg2238 n_152 n_150 n_157 VDD VSS / CLKXOR2X1
Xg2239 n_138 n_148 n_158 VDD VSS / XNOR2X1
Xg2240 n_152 n_3 n_156 VDD VSS / NOR2X1
Xg2241 n_152 n_3 n_155 VDD VSS / AND2X1
Xg2243 n_151 n_147 n_154 VDD VSS / NAND2X1
Xg2244 n_144 n_149 n_153 VDD VSS / OR2X1
Xg2245 n_138 n_146 n_151 VDD VSS / OR2X1
Xg2246 n_94 n_140 n_152 VDD VSS / CLKXOR2X1
Xg2247 b_2 n_135 n_148 VDD VSS / XNOR2X1
Xg2248 n_93 n_139 n_150 VDD VSS / CLKXOR2X1
Xg2249 n_125 n_134 n_149 VDD VSS / CLKXOR2X1
Xg2250 n_136 b_2 n_147 VDD VSS / NAND2X1
Xg2251 n_136 b_2 n_146 VDD VSS / NOR2X1
Xg2253 n_137 n_126 n_144 VDD VSS / AND2X1
Xg2254 n_137 n_141 n_143 VDD VSS / AND2X1
Xg2255 n_142 n_130 n_145 VDD VSS / NAND2X1
Xg2256 n_129 n_125 n_142 VDD VSS / NAND2X1
Xg2257 n_131 n_118 n_141 VDD VSS / NAND2X1
Xg2258 n_133 n_98 n_140 VDD VSS / NAND2X1
Xg2259 n_132 n_97 n_139 VDD VSS / NAND2X1
Xg2260 n_135 n_136 VDD VSS / CLKINVX1
Xg2261 b_1 n_124 n_134 VDD VSS / CLKXOR2X1
Xg2262 n_105 n_128 n_138 VDD VSS / CLKXOR2X1
Xg2263 n_118 n_131 n_137 VDD VSS / OR2X1
Xg2264 n_106 n_127 n_135 VDD VSS / CLKXOR2X1
Xg2265 n_128 n_100 n_133 VDD VSS / NAND2X1
Xg2266 n_127 n_99 n_132 VDD VSS / NAND2X1
Xg2267 n_123 b_1 n_130 VDD VSS / NAND2X1
Xg2268 n_124 n_4 n_129 VDD VSS / NAND2X1
Xg2269 n_126 n_122 n_131 VDD VSS / NAND2X1
Xg2270 n_120 n_113 n_128 VDD VSS / NAND2X1
Xg2271 n_121 n_0 n_127 VDD VSS / NAND2X1
Xg2272 n_119 b_0 n_126 VDD VSS / NAND2X1
Xg2273 n_124 n_123 VDD VSS / CLKINVX1
Xg2274 b_0 n_119 n_122 VDD VSS / OR2X1
Xg2275 n_115 n_116 n_125 VDD VSS / XNOR2X1
Xg2276 n_117 n_114 n_124 VDD VSS / CLKXOR2X1
Xg2277 n_117 n_108 n_121 VDD VSS / NAND2X1
Xg2278 n_116 n_107 n_120 VDD VSS / NAND2X1
Xg2279 n_84 n_109 n_119 VDD VSS / CLKXOR2X1
Xg2280 n_79 n_110 n_118 VDD VSS / XNOR2X1
Xg2281 n_111 n_104 n_117 VDD VSS / NAND2X1
Xg2282 n_112 n_102 n_116 VDD VSS / NAND2X1
Xg2283 n_107 n_113 n_115 VDD VSS / NAND2X1
Xg2284 n_0 n_108 n_114 VDD VSS / NAND2X1
Xg2285 n_101 n_79 n_112 VDD VSS / NAND2X1
Xg2286 n_103 n_84 n_111 VDD VSS / NAND2X1
Xg2287 n_101 n_102 n_110 VDD VSS / AND2X1
Xg2288 n_95 n_92 n_113 VDD VSS / NAND2X1
Xg2289 n_103 n_104 n_109 VDD VSS / AND2X1
Xg2290 n_96 n_89 n_108 VDD VSS / NAND2X1
Xg2291 n_92 n_95 n_107 VDD VSS / OR2X1
Xg2293 n_99 n_97 n_106 VDD VSS / NAND2X1
Xg2294 n_100 n_98 n_105 VDD VSS / NAND2X1
Xg2295 n_87 n_58 n_104 VDD VSS / NAND2X1
Xg2296 n_58 n_87 n_103 VDD VSS / OR2X1
Xg2297 n_88 n_48 n_102 VDD VSS / NAND2X1
Xg2298 n_48 n_88 n_101 VDD VSS / OR2X1
Xg2299 n_90 n_85 n_100 VDD VSS / NAND2X1
Xg2300 n_91 n_86 n_99 VDD VSS / NAND2X1
Xg2302 n_85 n_90 n_98 VDD VSS / OR2X1
Xg2303 n_86 n_91 n_97 VDD VSS / OR2X1
Xg2304 n_5 n_80 n_94 VDD VSS / CLKXOR2X1
Xg2305 n_65 n_76 n_96 VDD VSS / XNOR2X1
Xg2306 n_63 n_75 n_95 VDD VSS / CLKXOR2X1
Xg2307 n_22 n_81 n_93 VDD VSS / XNOR2X1
Xg2309 n_77 n_40 n_92 VDD VSS / NAND2X1
Xg2310 n_82 n_67 n_91 VDD VSS / NOR2X1
Xg2311 n_83 n_69 n_90 VDD VSS / NOR2X1
Xg2312 n_78 n_49 n_89 VDD VSS / NOR2X1
Xg2313 n_62 n_64 n_88 VDD VSS / XNOR2X1
Xg2314 n_59 n_66 n_87 VDD VSS / XNOR2X1
Xg2315 n_47 n_60 n_86 VDD VSS / XNOR2X1
Xg2316 n_46 n_61 n_85 VDD VSS / XNOR2X1
Xg2317 n_68 n_63 n_83 VDD VSS / NOR2X1
Xg2318 n_72 n_65 n_82 VDD VSS / AND2X1
Xg2319 n_71 n_41 n_81 VDD VSS / NAND2X1
Xg2320 n_74 n_39 n_80 VDD VSS / NOR2X1
Xg2321 n_56 n_70 n_84 VDD VSS / NOR2X1
Xg2322 n_66 n_42 n_78 VDD VSS / AND2X1
Xg2323 n_50 n_64 n_77 VDD VSS / OR2X1
Xg2324 n_8 n_43 n_76 VDD VSS / XNOR2X1
Xg2325 n_30 n_45 n_75 VDD VSS / CLKXOR2X1
Xg2326 n_54 n_73 n_79 VDD VSS / NOR2X1
Xg2327 n_38 n_46 n_74 VDD VSS / AND2X1
Xg2328 w1_1 n_55 n_73 VDD VSS / NAND2X1
Xg2329 n_43 n_9 n_72 VDD VSS / NAND2X1
Xg2330 n_52 n_47 n_71 VDD VSS / NAND2X1
Xg2331 w2_1 n_57 n_70 VDD VSS / NAND2X1
Xg2332 n_45 n_29 n_69 VDD VSS / NOR2X1
Xg2333 n_44 n_30 n_68 VDD VSS / NOR2X1
Xg2334 n_43 n_9 n_67 VDD VSS / NOR2X1
Xg2335 n_32 n_12 n_62 VDD VSS / XNOR2X1
Xg2336 n_14 n_33 n_61 VDD VSS / CLKXOR2X1
Xg2337 n_10 n_11 n_60 VDD VSS / CLKXOR2X1
Xg2338 n_27 n_31 n_59 VDD VSS / CLKXOR2X1
Xg2339 n_36 n_19 n_66 VDD VSS / XNOR2X1
Xg2340 n_47 n_53 n_65 VDD VSS / NAND2X1
Xg2341 n_16 n_18 n_64 VDD VSS / CLKXOR2X1
Xg2342 n_46 n_51 n_63 VDD VSS / AND2X1
Xg2343 n_6 x2_1 n_57 VDD VSS / AND2X1
Xg2344 n_26 w2_0 n_56 VDD VSS / NOR2X1
Xg2345 n_23 x1_1 n_55 VDD VSS / AND2X1
Xg2346 n_24 w1_0 n_54 VDD VSS / NOR2X1
Xg2347 n_35 n_37 n_53 VDD VSS / NAND2X1
Xg2348 n_11 n_10 n_52 VDD VSS / OR2X1
Xg2349 n_15 n_21 n_51 VDD VSS / NAND2X1
Xg2350 n_32 n_13 n_50 VDD VSS / NOR2X1
Xg2351 n_28 n_31 n_49 VDD VSS / NOR2X1
Xg2352 n_34 n_25 n_58 VDD VSS / NOR2X1
Xg2353 n_45 n_44 VDD VSS / CLKINVX1
Xg2354 n_28 n_31 n_42 VDD VSS / NAND2X1
Xg2355 n_11 n_10 n_41 VDD VSS / NAND2X1
Xg2356 n_13 n_32 n_40 VDD VSS / NAND2X1
Xg2357 n_33 n_14 n_39 VDD VSS / AND2X1
Xg2358 n_33 n_14 n_38 VDD VSS / OR2X1
Xg2359 n_15 n_7 n_48 VDD VSS / AND2X1
Xg2360 n_37 n_35 n_47 VDD VSS / OR2X1
Xg2361 n_21 n_15 n_46 VDD VSS / OR2X1
Xg2362 n_17 n_18 n_45 VDD VSS / NAND2X1
Xg2363 n_20 n_36 n_43 VDD VSS / NAND2X1
Xg2364 n_34 n_35 VDD VSS / CLKINVX1
Xg2365 n_30 n_29 VDD VSS / CLKINVX1
Xg2366 n_27 n_28 VDD VSS / CLKINVX1
Xg2367 w2_2 x2_0 n_26 VDD VSS / AND2X1
Xg2368 w2_0 x2_0 n_25 VDD VSS / NAND2X1
Xg2369 w1_2 x1_0 n_24 VDD VSS / AND2X1
Xg2370 x1_0 x1_2 n_23 VDD VSS / OR2X1
Xg2371 w2_1 x2_3 n_37 VDD VSS / NAND2X1
Xg2372 w2_3 x2_3 n_22 VDD VSS / NAND2X1
Xg2373 w2_0 x2_3 n_36 VDD VSS / NAND2X1
Xg2374 w2_2 x2_2 n_34 VDD VSS / NAND2X1
Xg2375 w1_2 x1_3 n_33 VDD VSS / NAND2X1
Xg2376 w1_3 x1_0 n_32 VDD VSS / NAND2X1
Xg2377 w2_2 x2_1 n_31 VDD VSS / NAND2X1
Xg2378 w1_3 x1_1 n_30 VDD VSS / NAND2X1
Xg2379 w2_3 x2_0 n_27 VDD VSS / NAND2X1
Xg2380 n_19 n_20 VDD VSS / CLKINVX1
Xg2381 n_16 n_17 VDD VSS / CLKINVX1
Xg2382 n_12 n_13 VDD VSS / CLKINVX1
Xg2383 n_8 n_9 VDD VSS / CLKINVX1
Xg2384 w1_0 x1_0 n_7 VDD VSS / AND2X1
Xg2385 x2_0 x2_2 n_6 VDD VSS / OR2X1
Xg2386 w1_1 x1_3 n_21 VDD VSS / NAND2X1
Xg2387 w1_3 x1_3 n_5 VDD VSS / NAND2X1
Xg2388 w2_1 x2_2 n_19 VDD VSS / NAND2X1
Xg2389 w1_0 x1_3 n_18 VDD VSS / NAND2X1
Xg2390 w1_1 x1_2 n_16 VDD VSS / NAND2X1
Xg2391 w1_2 x1_2 n_15 VDD VSS / AND2X1
Xg2392 w1_3 x1_2 n_14 VDD VSS / NAND2X1
Xg2393 w1_2 x1_1 n_12 VDD VSS / NAND2X1
Xg2394 w2_2 x2_3 n_11 VDD VSS / NAND2X1
Xg2395 w2_3 x2_2 n_10 VDD VSS / NAND2X1
Xg2396 w2_3 x2_1 n_8 VDD VSS / NAND2X1
Xg2397 b_1 n_4 VDD VSS / CLKINVX1
Xg2398 b_3 n_3 VDD VSS / CLKINVX1
Xg2 n_165 n_154 n_2 VDD VSS / AND2X1
Xg2399 n_158 n_145 n_1 VDD VSS / AND2X1
Xg2400 n_96 n_89 n_0 VDD VSS / OR2X1

.ENDS z2_4

*******************************************************************************
* MODULE: z2_4_88  (identical internal structure to z2_4, used for Z2_2)
*******************************************************************************
.SUBCKT z2_4_88 clk reset x1_0 x1_1 x1_2 x1_3 x2_0 x2_1 x2_2 x2_3 w1_0 w1_1 w1_2 w1_3 w2_0 w2_1 w2_2 w2_3 b_0 b_1 b_2 b_3 z_0 z_1 z_2 z_3 VDD VSS

Xz_reg_0 clk n_190 z_0 VDD VSS / DFFQX1
Xz_reg_1 clk n_192 z_1 VDD VSS / DFFQX1
Xz_reg_2 clk n_191 z_2 VDD VSS / DFFQX1
Xz_reg_3 clk n_183 z_3 VDD VSS / DFFQX1
Xg2199 n_187 n_189 n_192 VDD VSS / NOR2X1
Xg2200 n_186 n_189 n_191 VDD VSS / NOR2X1
Xg2201 n_188 n_189 n_190 VDD VSS / NOR2X1
Xg2202 n_185 n_143 n_188 VDD VSS / NOR2X1
Xg2203 reset n_184 n_189 VDD VSS / OR2X1
Xg2204 n_185 n_164 n_187 VDD VSS / NOR2X1
Xg2205 n_185 n_173 n_186 VDD VSS / NOR2X1
Xg2207 n_181 n_179 n_184 VDD VSS / AND2X1
Xg2208 n_179 n_182 n_185 VDD VSS / NOR2X1
Xg2209 n_180 reset n_183 VDD VSS / NOR2X1
Xg2210 n_178 n_176 n_182 VDD VSS / NOR2X1
Xg2211 n_178 n_176 n_181 VDD VSS / NAND2X1
Xg2212 n_179 n_180 VDD VSS / CLKINVX1
Xg2213 n_177 n_167 n_179 VDD VSS / NOR2X1
Xg2214 n_170 n_175 n_178 VDD VSS / CLKXOR2X1
Xg2215 n_175 n_168 n_177 VDD VSS / NOR2X1
Xg2216 n_171 n_172 n_176 VDD VSS / CLKXOR2X1
Xg2217 n_174 n_2 n_175 VDD VSS / NOR2X1
Xg2218 n_169 n_171 n_174 VDD VSS / NOR2X1
Xg2219 n_153 n_163 n_173 VDD VSS / CLKXOR2X1
Xg2220 n_169 n_2 n_172 VDD VSS / OR2X1
Xg2221 n_167 n_168 n_170 VDD VSS / OR2X1
Xg2222 n_166 n_1 n_171 VDD VSS / NOR2X1
Xg2224 n_165 n_154 n_169 VDD VSS / NOR2X1
Xg2225 n_161 n_153 n_166 VDD VSS / NOR2X1
Xg2226 n_162 b_3 n_168 VDD VSS / AND2X1
Xg2227 n_162 b_3 n_167 VDD VSS / NOR2X1
Xg2229 n_137 n_159 n_164 VDD VSS / CLKXOR2X1
Xg2230 n_161 n_1 n_163 VDD VSS / OR2X1
Xg2231 b_3 n_3 n_157 n_165 VDD VSS / MX2X1
Xg2232 n_160 n_156 n_162 VDD VSS / NOR2X1
Xg2234 n_158 n_145 n_161 VDD VSS / NOR2X1
Xg2235 n_155 n_150 n_160 VDD VSS / NOR2X1
Xg2236 n_126 n_149 n_159 VDD VSS / XNOR2X1
Xg2238 n_152 n_150 n_157 VDD VSS / CLKXOR2X1
Xg2239 n_138 n_148 n_158 VDD VSS / XNOR2X1
Xg2240 n_152 n_3 n_156 VDD VSS / NOR2X1
Xg2241 n_152 n_3 n_155 VDD VSS / AND2X1
Xg2243 n_151 n_147 n_154 VDD VSS / NAND2X1
Xg2244 n_144 n_149 n_153 VDD VSS / OR2X1
Xg2245 n_138 n_146 n_151 VDD VSS / OR2X1
Xg2246 n_94 n_140 n_152 VDD VSS / CLKXOR2X1
Xg2247 b_2 n_135 n_148 VDD VSS / XNOR2X1
Xg2248 n_93 n_139 n_150 VDD VSS / CLKXOR2X1
Xg2249 n_125 n_134 n_149 VDD VSS / CLKXOR2X1
Xg2250 n_136 b_2 n_147 VDD VSS / NAND2X1
Xg2251 n_136 b_2 n_146 VDD VSS / NOR2X1
Xg2253 n_137 n_126 n_144 VDD VSS / AND2X1
Xg2254 n_137 n_141 n_143 VDD VSS / AND2X1
Xg2255 n_142 n_130 n_145 VDD VSS / NAND2X1
Xg2256 n_129 n_125 n_142 VDD VSS / NAND2X1
Xg2257 n_131 n_118 n_141 VDD VSS / NAND2X1
Xg2258 n_133 n_98 n_140 VDD VSS / NAND2X1
Xg2259 n_132 n_97 n_139 VDD VSS / NAND2X1
Xg2260 n_135 n_136 VDD VSS / CLKINVX1
Xg2261 b_1 n_124 n_134 VDD VSS / CLKXOR2X1
Xg2262 n_105 n_128 n_138 VDD VSS / CLKXOR2X1
Xg2263 n_118 n_131 n_137 VDD VSS / OR2X1
Xg2264 n_106 n_127 n_135 VDD VSS / CLKXOR2X1
Xg2265 n_128 n_100 n_133 VDD VSS / NAND2X1
Xg2266 n_127 n_99 n_132 VDD VSS / NAND2X1
Xg2267 n_123 b_1 n_130 VDD VSS / NAND2X1
Xg2268 n_124 n_4 n_129 VDD VSS / NAND2X1
Xg2269 n_126 n_122 n_131 VDD VSS / NAND2X1
Xg2270 n_120 n_113 n_128 VDD VSS / NAND2X1
Xg2271 n_121 n_0 n_127 VDD VSS / NAND2X1
Xg2272 n_119 b_0 n_126 VDD VSS / NAND2X1
Xg2273 n_124 n_123 VDD VSS / CLKINVX1
Xg2274 b_0 n_119 n_122 VDD VSS / OR2X1
Xg2275 n_115 n_116 n_125 VDD VSS / XNOR2X1
Xg2276 n_117 n_114 n_124 VDD VSS / CLKXOR2X1
Xg2277 n_117 n_108 n_121 VDD VSS / NAND2X1
Xg2278 n_116 n_107 n_120 VDD VSS / NAND2X1
Xg2279 n_84 n_109 n_119 VDD VSS / CLKXOR2X1
Xg2280 n_79 n_110 n_118 VDD VSS / XNOR2X1
Xg2281 n_111 n_104 n_117 VDD VSS / NAND2X1
Xg2282 n_112 n_102 n_116 VDD VSS / NAND2X1
Xg2283 n_107 n_113 n_115 VDD VSS / NAND2X1
Xg2284 n_0 n_108 n_114 VDD VSS / NAND2X1
Xg2285 n_101 n_79 n_112 VDD VSS / NAND2X1
Xg2286 n_103 n_84 n_111 VDD VSS / NAND2X1
Xg2287 n_101 n_102 n_110 VDD VSS / AND2X1
Xg2288 n_95 n_92 n_113 VDD VSS / NAND2X1
Xg2289 n_103 n_104 n_109 VDD VSS / AND2X1
Xg2290 n_96 n_89 n_108 VDD VSS / NAND2X1
Xg2291 n_92 n_95 n_107 VDD VSS / OR2X1
Xg2293 n_99 n_97 n_106 VDD VSS / NAND2X1
Xg2294 n_100 n_98 n_105 VDD VSS / NAND2X1
Xg2295 n_87 n_58 n_104 VDD VSS / NAND2X1
Xg2296 n_58 n_87 n_103 VDD VSS / OR2X1
Xg2297 n_88 n_48 n_102 VDD VSS / NAND2X1
Xg2298 n_48 n_88 n_101 VDD VSS / OR2X1
Xg2299 n_90 n_85 n_100 VDD VSS / NAND2X1
Xg2300 n_91 n_86 n_99 VDD VSS / NAND2X1
Xg2302 n_85 n_90 n_98 VDD VSS / OR2X1
Xg2303 n_86 n_91 n_97 VDD VSS / OR2X1
Xg2304 n_5 n_80 n_94 VDD VSS / CLKXOR2X1
Xg2305 n_65 n_76 n_96 VDD VSS / XNOR2X1
Xg2306 n_63 n_75 n_95 VDD VSS / CLKXOR2X1
Xg2307 n_22 n_81 n_93 VDD VSS / XNOR2X1
Xg2309 n_77 n_40 n_92 VDD VSS / NAND2X1
Xg2310 n_82 n_67 n_91 VDD VSS / NOR2X1
Xg2311 n_83 n_69 n_90 VDD VSS / NOR2X1
Xg2312 n_78 n_49 n_89 VDD VSS / NOR2X1
Xg2313 n_62 n_64 n_88 VDD VSS / XNOR2X1
Xg2314 n_59 n_66 n_87 VDD VSS / XNOR2X1
Xg2315 n_47 n_60 n_86 VDD VSS / XNOR2X1
Xg2316 n_46 n_61 n_85 VDD VSS / XNOR2X1
Xg2317 n_68 n_63 n_83 VDD VSS / NOR2X1
Xg2318 n_72 n_65 n_82 VDD VSS / AND2X1
Xg2319 n_71 n_41 n_81 VDD VSS / NAND2X1
Xg2320 n_74 n_39 n_80 VDD VSS / NOR2X1
Xg2321 n_56 n_70 n_84 VDD VSS / NOR2X1
Xg2322 n_66 n_42 n_78 VDD VSS / AND2X1
Xg2323 n_50 n_64 n_77 VDD VSS / OR2X1
Xg2324 n_8 n_43 n_76 VDD VSS / XNOR2X1
Xg2325 n_30 n_45 n_75 VDD VSS / CLKXOR2X1
Xg2326 n_54 n_73 n_79 VDD VSS / NOR2X1
Xg2327 n_38 n_46 n_74 VDD VSS / AND2X1
Xg2328 w1_1 n_55 n_73 VDD VSS / NAND2X1
Xg2329 n_43 n_9 n_72 VDD VSS / NAND2X1
Xg2330 n_52 n_47 n_71 VDD VSS / NAND2X1
Xg2331 w2_1 n_57 n_70 VDD VSS / NAND2X1
Xg2332 n_45 n_29 n_69 VDD VSS / NOR2X1
Xg2333 n_44 n_30 n_68 VDD VSS / NOR2X1
Xg2334 n_43 n_9 n_67 VDD VSS / NOR2X1
Xg2335 n_32 n_12 n_62 VDD VSS / XNOR2X1
Xg2336 n_14 n_33 n_61 VDD VSS / CLKXOR2X1
Xg2337 n_10 n_11 n_60 VDD VSS / CLKXOR2X1
Xg2338 n_27 n_31 n_59 VDD VSS / CLKXOR2X1
Xg2339 n_36 n_19 n_66 VDD VSS / XNOR2X1
Xg2340 n_47 n_53 n_65 VDD VSS / NAND2X1
Xg2341 n_16 n_18 n_64 VDD VSS / CLKXOR2X1
Xg2342 n_46 n_51 n_63 VDD VSS / AND2X1
Xg2343 n_6 x2_1 n_57 VDD VSS / AND2X1
Xg2344 n_26 w2_0 n_56 VDD VSS / NOR2X1
Xg2345 n_23 x1_1 n_55 VDD VSS / AND2X1
Xg2346 n_24 w1_0 n_54 VDD VSS / NOR2X1
Xg2347 n_35 n_37 n_53 VDD VSS / NAND2X1
Xg2348 n_11 n_10 n_52 VDD VSS / OR2X1
Xg2349 n_15 n_21 n_51 VDD VSS / NAND2X1
Xg2350 n_32 n_13 n_50 VDD VSS / NOR2X1
Xg2351 n_28 n_31 n_49 VDD VSS / NOR2X1
Xg2352 n_34 n_25 n_58 VDD VSS / NOR2X1
Xg2353 n_45 n_44 VDD VSS / CLKINVX1
Xg2354 n_28 n_31 n_42 VDD VSS / NAND2X1
Xg2355 n_11 n_10 n_41 VDD VSS / NAND2X1
Xg2356 n_13 n_32 n_40 VDD VSS / NAND2X1
Xg2357 n_33 n_14 n_39 VDD VSS / AND2X1
Xg2358 n_33 n_14 n_38 VDD VSS / OR2X1
Xg2359 n_15 n_7 n_48 VDD VSS / AND2X1
Xg2360 n_37 n_35 n_47 VDD VSS / OR2X1
Xg2361 n_21 n_15 n_46 VDD VSS / OR2X1
Xg2362 n_17 n_18 n_45 VDD VSS / NAND2X1
Xg2363 n_20 n_36 n_43 VDD VSS / NAND2X1
Xg2364 n_34 n_35 VDD VSS / CLKINVX1
Xg2365 n_30 n_29 VDD VSS / CLKINVX1
Xg2366 n_27 n_28 VDD VSS / CLKINVX1
Xg2367 w2_2 x2_0 n_26 VDD VSS / AND2X1
Xg2368 w2_0 x2_0 n_25 VDD VSS / NAND2X1
Xg2369 w1_2 x1_0 n_24 VDD VSS / AND2X1
Xg2370 x1_0 x1_2 n_23 VDD VSS / OR2X1
Xg2371 w2_1 x2_3 n_37 VDD VSS / NAND2X1
Xg2372 w2_3 x2_3 n_22 VDD VSS / NAND2X1
Xg2373 w2_0 x2_3 n_36 VDD VSS / NAND2X1
Xg2374 w2_2 x2_2 n_34 VDD VSS / NAND2X1
Xg2375 w1_2 x1_3 n_33 VDD VSS / NAND2X1
Xg2376 w1_3 x1_0 n_32 VDD VSS / NAND2X1
Xg2377 w2_2 x2_1 n_31 VDD VSS / NAND2X1
Xg2378 w1_3 x1_1 n_30 VDD VSS / NAND2X1
Xg2379 w2_3 x2_0 n_27 VDD VSS / NAND2X1
Xg2380 n_19 n_20 VDD VSS / CLKINVX1
Xg2381 n_16 n_17 VDD VSS / CLKINVX1
Xg2382 n_12 n_13 VDD VSS / CLKINVX1
Xg2383 n_8 n_9 VDD VSS / CLKINVX1
Xg2384 w1_0 x1_0 n_7 VDD VSS / AND2X1
Xg2385 x2_0 x2_2 n_6 VDD VSS / OR2X1
Xg2386 w1_1 x1_3 n_21 VDD VSS / NAND2X1
Xg2387 w1_3 x1_3 n_5 VDD VSS / NAND2X1
Xg2388 w2_1 x2_2 n_19 VDD VSS / NAND2X1
Xg2389 w1_0 x1_3 n_18 VDD VSS / NAND2X1
Xg2390 w1_1 x1_2 n_16 VDD VSS / NAND2X1
Xg2391 w1_2 x1_2 n_15 VDD VSS / AND2X1
Xg2392 w1_3 x1_2 n_14 VDD VSS / NAND2X1
Xg2393 w1_2 x1_1 n_12 VDD VSS / NAND2X1
Xg2394 w2_2 x2_3 n_11 VDD VSS / NAND2X1
Xg2395 w2_3 x2_2 n_10 VDD VSS / NAND2X1
Xg2396 w2_3 x2_1 n_8 VDD VSS / NAND2X1
Xg2397 b_1 n_4 VDD VSS / CLKINVX1
Xg2398 b_3 n_3 VDD VSS / CLKINVX1
Xg2 n_165 n_154 n_2 VDD VSS / AND2X1
Xg2399 n_158 n_145 n_1 VDD VSS / AND2X1
Xg2400 n_96 n_89 n_0 VDD VSS / OR2X1

.ENDS z2_4_88

*******************************************************************************
* MODULE: z2_4_87  (output neuron MAC Z3_1 — different adder structure)
*******************************************************************************
.SUBCKT z2_4_87 clk reset x1_0 x1_1 x1_2 x1_3 x2_0 x2_1 x2_2 x2_3 w1_0 w1_1 w1_2 w1_3 w2_0 w2_1 w2_2 w2_3 b_0 b_1 b_2 b_3 z_0 z_1 z_2 z_3 VDD VSS

Xz_reg_0 clk n_185 z_0 VDD VSS / DFFQX1
Xz_reg_1 clk n_187 z_1 VDD VSS / DFFQX1
Xz_reg_2 clk n_186 z_2 VDD VSS / DFFQX1
Xz_reg_3 clk n_178 z_3 VDD VSS / DFFQX1
Xg2199 n_182 n_184 n_187 VDD VSS / NOR2X1
Xg2200 n_181 n_184 n_186 VDD VSS / NOR2X1
Xg2201 n_183 n_184 n_185 VDD VSS / NOR2X1
Xg2202 n_180 n_139 n_183 VDD VSS / NOR2X1
Xg2203 reset n_179 n_184 VDD VSS / OR2X1
Xg2204 n_180 n_160 n_182 VDD VSS / NOR2X1
Xg2205 n_180 n_168 n_181 VDD VSS / NOR2X1
Xg2207 n_176 n_174 n_179 VDD VSS / AND2X1
Xg2208 n_174 n_177 n_180 VDD VSS / NOR2X1
Xg2209 n_175 reset n_178 VDD VSS / NOR2X1
Xg2210 n_173 n_171 n_177 VDD VSS / NOR2X1
Xg2211 n_173 n_171 n_176 VDD VSS / NAND2X1
Xg2212 n_174 n_175 VDD VSS / CLKINVX1
Xg2213 n_172 n_162 n_174 VDD VSS / NOR2X1
Xg2214 n_165 n_170 n_173 VDD VSS / XNOR2X1
Xg2215 n_170 n_163 n_172 VDD VSS / NOR2X1
Xg2216 n_166 n_167 n_171 VDD VSS / CLKXOR2X1
Xg2217 n_169 n_3 n_170 VDD VSS / NOR2X1
Xg2218 n_164 n_166 n_169 VDD VSS / NOR2X1
Xg2219 n_149 n_159 n_168 VDD VSS / CLKXOR2X1
Xg2220 n_164 n_3 n_167 VDD VSS / OR2X1
Xg2221 n_163 n_162 n_165 VDD VSS / NOR2X1
Xg2222 n_161 n_2 n_166 VDD VSS / NOR2X1
Xg2224 n_0 n_150 n_164 VDD VSS / NOR2X1
Xg2225 n_157 n_149 n_161 VDD VSS / NOR2X1
Xg2226 b_3 n_158 n_163 VDD VSS / AND2X1
Xg2227 b_3 n_158 n_162 VDD VSS / NOR2X1
Xg2229 n_133 n_155 n_160 VDD VSS / CLKXOR2X1
Xg2230 n_157 n_2 n_159 VDD VSS / OR2X1
Xg2232 n_156 n_152 n_158 VDD VSS / NOR2X1
Xg2234 n_154 n_141 n_157 VDD VSS / NOR2X1
Xg2235 n_146 n_151 n_156 VDD VSS / NOR2X1
Xg2236 n_122 n_145 n_155 VDD VSS / XNOR2X1
Xg2238 n_148 n_146 n_153 VDD VSS / CLKXOR2X1
Xg2239 n_134 n_144 n_154 VDD VSS / XNOR2X1
Xg2240 b_3 n_148 n_152 VDD VSS / AND2X1
Xg2241 b_3 n_148 n_151 VDD VSS / NOR2X1
Xg2243 n_147 n_143 n_150 VDD VSS / NAND2X1
Xg2244 n_140 n_145 n_149 VDD VSS / OR2X1
Xg2245 n_134 n_142 n_147 VDD VSS / OR2X1
Xg2246 n_91 n_136 n_148 VDD VSS / CLKXOR2X1
Xg2247 n_131 b_2 n_144 VDD VSS / XNOR2X1
Xg2248 n_90 n_135 n_146 VDD VSS / CLKXOR2X1
Xg2249 n_121 n_130 n_145 VDD VSS / XNOR2X1
Xg2250 b_2 n_132 n_143 VDD VSS / NAND2X1
Xg2251 b_2 n_132 n_142 VDD VSS / NOR2X1
Xg2253 n_133 n_122 n_140 VDD VSS / AND2X1
Xg2254 n_133 n_137 n_139 VDD VSS / AND2X1
Xg2255 n_138 n_126 n_141 VDD VSS / NAND2X1
Xg2256 n_121 n_125 n_138 VDD VSS / OR2X1
Xg2257 n_127 n_115 n_137 VDD VSS / NAND2X1
Xg2258 n_129 n_95 n_136 VDD VSS / NAND2X1
Xg2259 n_128 n_94 n_135 VDD VSS / NAND2X1
Xg2260 n_131 n_132 VDD VSS / CLKINVX1
Xg2261 n_120 b_1 n_130 VDD VSS / XNOR2X1
Xg2262 n_102 n_124 n_134 VDD VSS / CLKXOR2X1
Xg2263 n_115 n_127 n_133 VDD VSS / OR2X1
Xg2264 n_103 n_123 n_131 VDD VSS / CLKXOR2X1
Xg2265 n_124 n_97 n_129 VDD VSS / NAND2X1
Xg2266 n_123 n_96 n_128 VDD VSS / NAND2X1
Xg2267 b_1 n_120 n_126 VDD VSS / NAND2X1
Xg2268 b_1 n_120 n_125 VDD VSS / NOR2X1
Xg2269 n_122 n_119 n_127 VDD VSS / NAND2X1
Xg2270 n_117 n_110 n_124 VDD VSS / NAND2X1
Xg2271 n_118 n_1 n_123 VDD VSS / NAND2X1
Xg2272 b_0 n_116 n_122 VDD VSS / NAND2X1
Xg2273 n_116 b_0 n_119 VDD VSS / OR2X1
Xg2274 n_113 n_112 n_121 VDD VSS / CLKXOR2X1
Xg2275 n_114 n_111 n_120 VDD VSS / XNOR2X1
Xg2276 n_114 n_105 n_118 VDD VSS / NAND2X1
Xg2277 n_113 n_104 n_117 VDD VSS / NAND2X1
Xg2278 n_81 n_106 n_116 VDD VSS / XNOR2X1
Xg2279 n_76 n_107 n_115 VDD VSS / XNOR2X1
Xg2280 n_108 n_101 n_114 VDD VSS / NAND2X1
Xg2281 n_109 n_99 n_113 VDD VSS / NAND2X1
Xg2282 n_104 n_110 n_112 VDD VSS / NAND2X1
Xg2283 n_1 n_105 n_111 VDD VSS / NAND2X1
Xg2284 n_98 n_76 n_109 VDD VSS / NAND2X1
Xg2285 n_100 n_81 n_108 VDD VSS / NAND2X1
Xg2286 n_98 n_99 n_107 VDD VSS / AND2X1
Xg2287 n_92 n_89 n_110 VDD VSS / NAND2X1
Xg2288 n_100 n_101 n_106 VDD VSS / NAND2X1
Xg2289 n_93 n_86 n_105 VDD VSS / NAND2X1
Xg2290 n_89 n_92 n_104 VDD VSS / OR2X1
Xg2292 n_96 n_94 n_103 VDD VSS / NAND2X1
Xg2293 n_97 n_95 n_102 VDD VSS / NAND2X1
Xg2294 n_84 n_55 n_101 VDD VSS / NAND2X1
Xg2295 n_55 n_84 n_100 VDD VSS / OR2X1
Xg2296 n_85 n_45 n_99 VDD VSS / NAND2X1
Xg2297 n_45 n_85 n_98 VDD VSS / OR2X1
Xg2298 n_87 n_82 n_97 VDD VSS / NAND2X1
Xg2299 n_88 n_83 n_96 VDD VSS / NAND2X1
Xg2301 n_82 n_87 n_95 VDD VSS / OR2X1
Xg2302 n_83 n_88 n_94 VDD VSS / OR2X1
Xg2303 n_4 n_77 n_91 VDD VSS / XNOR2X1
Xg2304 n_62 n_73 n_93 VDD VSS / CLKXOR2X1
Xg2305 n_60 n_72 n_92 VDD VSS / XNOR2X1
Xg2306 n_18 n_78 n_90 VDD VSS / XNOR2X1
Xg2308 n_74 n_37 n_89 VDD VSS / NAND2X1
Xg2309 n_79 n_64 n_88 VDD VSS / NOR2X1
Xg2310 n_80 n_66 n_87 VDD VSS / NOR2X1
Xg2311 n_75 n_46 n_86 VDD VSS / NOR2X1
Xg2312 n_59 n_61 n_85 VDD VSS / XNOR2X1
Xg2313 n_56 n_63 n_84 VDD VSS / XNOR2X1
Xg2314 n_44 n_57 n_83 VDD VSS / CLKXOR2X1
Xg2315 n_43 n_58 n_82 VDD VSS / XNOR2X1
Xg2316 n_65 n_60 n_80 VDD VSS / NOR2X1
Xg2317 n_69 n_62 n_79 VDD VSS / NOR2X1
Xg2318 n_68 n_38 n_78 VDD VSS / NAND2X1
Xg2319 n_71 n_36 n_77 VDD VSS / NOR2X1
Xg2320 n_67 n_53 n_81 VDD VSS / NOR2X1
Xg2321 n_63 n_39 n_75 VDD VSS / AND2X1
Xg2322 n_61 n_47 n_74 VDD VSS / NAND2X1
Xg2323 n_7 n_40 n_73 VDD VSS / CLKXOR2X1
Xg2324 n_26 n_42 n_72 VDD VSS / XNOR2X1
Xg2325 n_70 n_51 n_76 VDD VSS / NOR2X1
Xg2326 n_35 n_43 n_71 VDD VSS / NOR2X1
Xg2327 w1_1 n_52 n_70 VDD VSS / NAND2X1
Xg2328 n_40 n_7 n_69 VDD VSS / NOR2X1
Xg2329 n_44 n_49 n_68 VDD VSS / OR2X1
Xg2330 w2_1 n_54 n_67 VDD VSS / NAND2X1
Xg2331 n_42 n_25 n_66 VDD VSS / NOR2X1
Xg2332 n_41 n_26 n_65 VDD VSS / NOR2X1
Xg2333 n_40 n_7 n_64 VDD VSS / AND2X1
Xg2334 n_28 n_10 n_59 VDD VSS / CLKXOR2X1
Xg2335 n_11 n_30 n_58 VDD VSS / XNOR2X1
Xg2336 n_8 n_9 n_57 VDD VSS / CLKXOR2X1
Xg2337 n_23 n_27 n_56 VDD VSS / CLKXOR2X1
Xg2338 n_16 n_32 n_63 VDD VSS / XNOR2X1
Xg2339 n_44 n_50 n_62 VDD VSS / NOR2X1
Xg2340 n_13 n_15 n_61 VDD VSS / XNOR2X1
Xg2341 n_43 n_48 n_60 VDD VSS / NOR2X1
Xg2342 n_5 x2_1 n_54 VDD VSS / AND2X1
Xg2343 w2_0 n_22 n_53 VDD VSS / NOR2X1
Xg2344 n_19 x1_1 n_52 VDD VSS / AND2X1
Xg2345 w1_0 n_20 n_51 VDD VSS / NOR2X1
Xg2346 n_34 n_31 n_50 VDD VSS / NOR2X1
Xg2347 n_9 n_8 n_49 VDD VSS / NOR2X1
Xg2348 n_17 n_12 n_48 VDD VSS / NOR2X1
Xg2349 n_29 n_10 n_47 VDD VSS / NAND2X1
Xg2350 n_27 n_24 n_46 VDD VSS / NOR2X1
Xg2351 n_31 n_21 n_55 VDD VSS / NOR2X1
Xg2352 n_42 n_41 VDD VSS / CLKINVX1
Xg2353 n_24 n_27 n_39 VDD VSS / NAND2X1
Xg2354 n_9 n_8 n_38 VDD VSS / NAND2X1
Xg2355 n_10 n_29 n_37 VDD VSS / OR2X1
Xg2356 n_11 n_30 n_36 VDD VSS / AND2X1
Xg2357 n_30 n_11 n_35 VDD VSS / NOR2X1
Xg2358 n_12 n_6 n_45 VDD VSS / NOR2X1
Xg2359 n_34 n_31 n_44 VDD VSS / AND2X1
Xg2360 n_17 n_12 n_43 VDD VSS / AND2X1
Xg2361 n_14 n_15 n_42 VDD VSS / NAND2X1
Xg2362 n_16 n_33 n_40 VDD VSS / NOR2X1
Xg2363 n_32 n_33 VDD VSS / CLKINVX1
Xg2364 n_28 n_29 VDD VSS / CLKINVX1
Xg2365 n_26 n_25 VDD VSS / CLKINVX1
Xg2366 n_23 n_24 VDD VSS / CLKINVX1
Xg2367 w2_2 x2_0 n_22 VDD VSS / AND2X1
Xg2368 w2_0 x2_0 n_21 VDD VSS / NAND2X1
Xg2369 w1_2 x1_0 n_20 VDD VSS / AND2X1
Xg2370 x1_0 x1_2 n_19 VDD VSS / OR2X1
Xg2371 w2_1 x2_3 n_34 VDD VSS / AND2X1
Xg2372 w2_3 x2_3 n_18 VDD VSS / NAND2X1
Xg2373 w2_0 x2_3 n_32 VDD VSS / NAND2X1
Xg2374 w2_2 x2_2 n_31 VDD VSS / NAND2X1
Xg2375 w1_2 x1_3 n_30 VDD VSS / NAND2X1
Xg2376 w1_3 x1_0 n_28 VDD VSS / NAND2X1
Xg2377 w2_2 x2_1 n_27 VDD VSS / NAND2X1
Xg2378 w1_3 x1_1 n_26 VDD VSS / NAND2X1
Xg2379 w2_3 x2_0 n_23 VDD VSS / NAND2X1
Xg2380 n_13 n_14 VDD VSS / CLKINVX1
Xg2381 w1_0 x1_0 n_6 VDD VSS / NAND2X1
Xg2382 x2_0 x2_2 n_5 VDD VSS / OR2X1
Xg2383 w1_1 x1_3 n_17 VDD VSS / AND2X1
Xg2384 w1_3 x1_3 n_4 VDD VSS / NAND2X1
Xg2385 w2_1 x2_2 n_16 VDD VSS / NAND2X1
Xg2386 w1_0 x1_3 n_15 VDD VSS / NAND2X1
Xg2387 w1_1 x1_2 n_13 VDD VSS / NAND2X1
Xg2388 w1_2 x1_2 n_12 VDD VSS / NAND2X1
Xg2389 w1_3 x1_2 n_11 VDD VSS / NAND2X1
Xg2390 w1_2 x1_1 n_10 VDD VSS / NAND2X1
Xg2391 w2_2 x2_3 n_9 VDD VSS / NAND2X1
Xg2392 w2_3 x2_2 n_8 VDD VSS / NAND2X1
Xg2393 w2_3 x2_1 n_7 VDD VSS / NAND2X1
Xg2 n_0 n_150 n_3 VDD VSS / AND2X1
Xg2395 n_154 n_141 n_2 VDD VSS / AND2X1
Xg2396 n_93 n_86 n_1 VDD VSS / OR2X1
Xg2397 b_3 n_153 n_0 VDD VSS / XNOR2X1

.ENDS z2_4_87

*******************************************************************************
* MODULE: forward4  (TOP of this file)
* Internal nets: addr[3:0] b2_1[3:0] b2_2[3:0] b3_1[3:0]
*                w2_11[3:0] w2_12[3:0] w2_21[3:0] w2_22[3:0]
*                z2_1[3:0] z2_2[3:0] z3_1[3:0] k1_rom[2:1] k2_rom[2:1]
*                select_update n_0 n_2 n_4 n_6 n_11
* UNCONNECTED* nodes are floating (Genus disconnected)
* VDD used for DIN=1'b1 on mem4 instances
*******************************************************************************
.SUBCKT forward4
+ clk reset din select_initial update_coeff
+ input_k1_0 input_k1_1 input_k1_2 input_k1_3
+ input_k2_0 input_k2_1 input_k2_2 input_k2_3
+ cap_dw2_11_0 cap_dw2_11_1 cap_dw2_11_2 cap_dw2_11_3
+ cap_dw2_21_0 cap_dw2_21_1 cap_dw2_21_2 cap_dw2_21_3
+ cap_dw2_12_0 cap_dw2_12_1 cap_dw2_12_2 cap_dw2_12_3
+ cap_dw2_22_0 cap_dw2_22_1 cap_dw2_22_2 cap_dw2_22_3
+ cap_dw3_11_0 cap_dw3_11_1 cap_dw3_11_2 cap_dw3_11_3
+ cap_dw3_21_0 cap_dw3_21_1 cap_dw3_21_2 cap_dw3_21_3
+ cap_db2_1_0 cap_db2_1_1 cap_db2_1_2 cap_db2_1_3
+ cap_db2_2_0 cap_db2_2_1 cap_db2_2_2 cap_db2_2_3
+ cap_db3_1_0 cap_db3_1_1 cap_db3_1_2 cap_db3_1_3
+ w3_11_0 w3_11_1 w3_11_2 w3_11_3
+ w3_21_0 w3_21_1 w3_21_2 w3_21_3
+ a2_1_0 a2_1_1 a2_1_2 a2_1_3
+ a2_2_0 a2_2_1 a2_2_2 a2_2_3
+ a3_1_0 a3_1_1 a3_1_2 a3_1_3
+ k1_out_0 k1_out_1 k1_out_2 k1_out_3
+ k2_out_0 k2_out_1 k2_out_2 k2_out_3
+ t1_out_0 t1_out_1 t1_out_2 t1_out_3
+ finish_updating VDD VSS

*--- Inverter control logic ---*
* n_0 = ~reset; n_6 = ~n_0 = reset_buf; n_11 = ~n_0 = reset_buf2
* n_2 = ~select_update; n_4 = ~n_2 = select_update_buf
Xg10 reset n_0 VDD VSS / CLKINVX1
Xg14 n_0 n_6 VDD VSS / CLKINVX1
Xg9 n_0 n_11 VDD VSS / CLKINVX1
Xg7 select_update n_2 VDD VSS / CLKINVX1
Xg4 n_2 n_4 VDD VSS / CLKINVX1

*--- Counter (generates addr[3:0]) ---*
* reset fed through n_11 (buffered reset)
XCNT clk n_11 addr_0 addr_1 addr_2 addr_3 UNCONNECTED33 VDD VSS / counter4

*--- Selector (generates select_update / enable_update) ---*
XSEL clk n_11 update_coeff select_update VDD VSS / selector4

*--- Input ROMs ---*
* k1: addr[0] unconnected (only addr[3:1] used), k_out[0,3] float
XK1 clk UNCONNECTED_HIER_Z34 UNCONNECTED_HIER_Z35 addr_1 addr_2 addr_3
+ UNCONNECTED34 k1_rom_1 k1_rom_2 UNCONNECTED35 VDD VSS / k1_rom4
* k2: addr[1] unconnected (addr[3:2]+addr[0] used), k_out[0,3] float
XK2 clk UNCONNECTED_HIER_Z36 addr_0 UNCONNECTED_HIER_Z37 addr_2 addr_3
+ UNCONNECTED36 k2_rom_1 k2_rom_2 UNCONNECTED37 VDD VSS / k2_rom4
* t1: only t_out[2] driven (maps to t1_out[2])
XT1 clk UNCONNECTED_HIER_Z42 addr_0 addr_1 addr_2 addr_3
+ UNCONNECTED38 UNCONNECTED39 t1_out_2 UNCONNECTED40 VDD VSS / t1_rom4

*--- Input selectors (ROM vs external) ---*
XSK1 input_k1_0 input_k1_1 input_k1_2 input_k1_3
+ UNCONNECTED_HIER_Z38 k1_rom_1 k1_rom_2 UNCONNECTED_HIER_Z39
+ update_coeff k1_out_0 k1_out_1 k1_out_2 k1_out_3 VDD VSS / sel_k4
XSK2 input_k2_0 input_k2_1 input_k2_2 input_k2_3
+ UNCONNECTED_HIER_Z40 k2_rom_1 k2_rom_2 UNCONNECTED_HIER_Z41
+ update_coeff k2_out_0 k2_out_1 k2_out_2 k2_out_3 VDD VSS / sel_k4_86

*--- Bias registers (init=-8=-1.0 Q1.3) ---*
* B2_1: hidden neuron 1 bias, reset=reset, sel_u=select_update_buf(n_4)
XB2_1 clk reset select_initial n_4
+ cap_db2_1_0 UNCONNECTED_HIER_Z26 UNCONNECTED_HIER_Z27 UNCONNECTED_HIER_Z28
+ b2_1_0 b2_1_1 b2_1_2 b2_1_3 VDD VSS / b_reg4_INITn8
* B2_2: hidden neuron 2 bias, reset=n_6 (buffered)
XB2_2 clk n_6 select_initial n_4
+ cap_db2_2_0 UNCONNECTED_HIER_Z29 UNCONNECTED_HIER_Z30 UNCONNECTED_HIER_Z31
+ b2_2_0 b2_2_1 b2_2_2 b2_2_3 VDD VSS / b_reg4_INITn8_37
* B3_1: output neuron bias, reset=n_6, db[1:0] connected
XB3_1 clk n_6 select_initial n_4
+ cap_db3_1_0 cap_db3_1_1 UNCONNECTED_HIER_Z32 UNCONNECTED_HIER_Z33
+ b3_1_0 b3_1_1 b3_1_2 b3_1_3 VDD VSS / b_reg4_INITn8_36

*--- Weight registers ---*
* W2_11: w2_11 init=1, reset=n_11, sel_u=select_update
XW2_11 clk n_11 select_initial select_update
+ cap_dw2_11_0 cap_dw2_11_1 UNCONNECTED_HIER_Z43 UNCONNECTED_HIER_Z44
+ w2_11_0 w2_11_1 w2_11_2 w2_11_3 VDD VSS / w_reg4_INIT1
* W2_12: w2_12 init=2, reset=n_11
XW2_12 clk n_11 select_initial select_update
+ cap_dw2_12_0 cap_dw2_12_1 UNCONNECTED_HIER_Z45 UNCONNECTED_HIER_Z46
+ w2_12_0 w2_12_1 w2_12_2 w2_12_3 VDD VSS / w_reg4_INIT2
* W2_21: w2_21 init=3, reset=n_11
XW2_21 clk n_11 select_initial select_update
+ cap_dw2_21_0 cap_dw2_21_1 UNCONNECTED_HIER_Z47 UNCONNECTED_HIER_Z48
+ w2_21_0 w2_21_1 w2_21_2 w2_21_3 VDD VSS / w_reg4_INIT3
* W2_22: w2_22 init=4, reset=reset (NOT n_11), sel_u=n_4
XW2_22 clk reset select_initial n_4
+ cap_dw2_22_0 cap_dw2_22_1 UNCONNECTED_HIER_Z49 UNCONNECTED_HIER_Z50
+ w2_22_0 w2_22_1 w2_22_2 w2_22_3 VDD VSS / w_reg4_INIT4
* W3_11: w3_11 init=5, reset=n_11, sel_u=n_4 — output port w3_11[3:0]
XW3_11 clk n_11 select_initial n_4
+ cap_dw3_11_0 cap_dw3_11_1 UNCONNECTED_HIER_Z51 UNCONNECTED_HIER_Z52
+ w3_11_0 w3_11_1 w3_11_2 w3_11_3 VDD VSS / w_reg4_INIT5
* W3_21: w3_21 init=7, reset=n_6, sel_u=select_update — output port w3_21[3:0]
XW3_21 clk n_6 select_initial select_update
+ cap_dw3_21_0 cap_dw3_21_1 UNCONNECTED_HIER_Z53 UNCONNECTED_HIER_Z54
+ w3_21_0 w3_21_1 w3_21_2 w3_21_3 VDD VSS / w_reg4_INIT7

*--- MAC units ---*
* Z2_1: hidden neuron 1 (x1=k1_out, x2=k2_out, w1=w2_11, w2=w2_21, b=b2_1)
XZ2_1 clk reset
+ k1_out_0 k1_out_1 k1_out_2 k1_out_3
+ k2_out_0 k2_out_1 k2_out_2 k2_out_3
+ w2_11_0 w2_11_1 w2_11_2 w2_11_3
+ w2_21_0 w2_21_1 w2_21_2 w2_21_3
+ b2_1_0 b2_1_1 b2_1_2 b2_1_3
+ z2_1_0 z2_1_1 z2_1_2 z2_1_3 VDD VSS / z2_4
* Z2_2: hidden neuron 2 (x1=k1_out, x2=k2_out, w1=w2_12, w2=w2_22, b=b2_2)
XZ2_2 clk reset
+ k1_out_0 k1_out_1 k1_out_2 k1_out_3
+ k2_out_0 k2_out_1 k2_out_2 k2_out_3
+ w2_12_0 w2_12_1 w2_12_2 w2_12_3
+ w2_22_0 w2_22_1 w2_22_2 w2_22_3
+ b2_2_0 b2_2_1 b2_2_2 b2_2_3
+ z2_2_0 z2_2_1 z2_2_2 z2_2_3 VDD VSS / z2_4_88
* Z3_1: output neuron (x1=a2_1, x2=a2_2, w1=w3_11, w2=w3_21, b=b3_1)
* reset = n_6 (buffered reset)
XZ3_1 clk n_6
+ a2_1_0 a2_1_1 a2_1_2 a2_1_3
+ a2_2_0 a2_2_1 a2_2_2 a2_2_3
+ w3_11_0 w3_11_1 w3_11_2 w3_11_3
+ w3_21_0 w3_21_1 w3_21_2 w3_21_3
+ b3_1_0 b3_1_1 b3_1_2 b3_1_3
+ z3_1_0 z3_1_1 z3_1_2 z3_1_3 VDD VSS / z2_4_87

*--- Sigmoid LUTs (mem4, DIN=VDD=1'b1) ---*
XSIG2_1 clk VDD z2_1_3 z2_1_2 z2_1_1 z2_1_0
+ a2_1_3 a2_1_2 a2_1_1 a2_1_0 VDD VSS / mem4
XSIG2_2 clk VDD z2_2_3 z2_2_2 z2_2_1 z2_2_0
+ a2_2_3 a2_2_2 a2_2_1 a2_2_0 VDD VSS / mem4
XSIG3_1 clk VDD z3_1_3 z3_1_2 z3_1_1 z3_1_0
+ a3_1_3 a3_1_2 a3_1_1 a3_1_0 VDD VSS / mem4

.ENDS forward4

* End of forward4.cdl
* Total sub-modules: 18
* Leaf cells: INVX1 DFFQX1 NOR2X1 NAND2X1 AND2X1 OR2X1 XOR2X1 XNOR2X1 MX2X1
* Wrappers: CLKINVX1 CLKXOR2X1 SDFFQX1
* Custom: mem4 (stub, real in stdcel lib)
