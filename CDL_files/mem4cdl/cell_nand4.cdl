**** NAND4 — 4-Input NAND Gate ****
* Ports: A B C D(in) Y(out) VDD VSS
* Y = NOT(A AND B AND C AND D)
* NMOS W=800n (4x min) to compensate 4-series stack

.SUBCKT NAND4 A B C D Y VDD VSS
*.PININFO A:I B:I C:I D:I Y:O VDD:I VSS:I
MP1 Y A VDD VDD pmos1v W=420n L=100n
MP2 Y B VDD VDD pmos1v W=420n L=100n
MP3 Y C VDD VDD pmos1v W=420n L=100n
MP4 Y D VDD VDD pmos1v W=420n L=100n
MN1 Y    A n1  VSS nmos1v W=800n L=100n
MN2 n1   B n2  VSS nmos1v W=800n L=100n
MN3 n2   C n3  VSS nmos1v W=800n L=100n
MN4 n3   D VSS VSS nmos1v W=800n L=100n
.ENDS NAND4
