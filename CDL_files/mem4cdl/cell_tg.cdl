**** TG — Transmission Gate (Pass Gate) ****
* Ports: IN OUT E Eb VDD VSS
* Passes IN to OUT when E=1 (Eb=0)
* NMOS gate=E, PMOS gate=Eb

.SUBCKT TG IN OUT E Eb VDD VSS
*.PININFO IN:I OUT:O E:I Eb:I VDD:I VSS:I
MN OUT IN E   VSS nmos1v W=200n L=100n
MP OUT IN Eb  VDD pmos1v W=420n L=100n
.ENDS TG
