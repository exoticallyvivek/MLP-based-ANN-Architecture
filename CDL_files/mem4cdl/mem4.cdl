* ============================================================
* mem4.cdl — 16x4-bit Sigmoid LUT ROM
* Uses gpdk090 nmos1v (W=200n L=100n) + pmos1v (W=420n L=100n)
* Architecture: NOR ROM + 4-to-16 decoder + output D-latches
* Ports: CLK DIN ADDR<3:0> DOUT<3:0> VDD VSS
* DOUT[3] always 0 → tied to VSS (values 2,3,4,5,6 have MSB=0)
* ============================================================

.subckt INV A Y VDD VSS
* Basic inverter: Y = NOT(A)
MP Y A VDD VDD pmos1v W=420n L=100n
MN Y A VSS VSS nmos1v W=200n L=100n
.ends INV

.subckt NAND2 A B Y VDD VSS
* 2-input NAND: Y = NOT(A AND B)
MP1 Y A VDD VDD pmos1v W=420n L=100n
MP2 Y B VDD VDD pmos1v W=420n L=100n
MN1 Y A net1 VSS nmos1v W=200n L=100n
MN2 net1 B VSS VSS nmos1v W=200n L=100n
.ends NAND2

.subckt NAND4 A B C D Y VDD VSS
* 4-input NAND: Y = NOT(A AND B AND C AND D)
* PMOS parallel pull-up (W=420n each, only 1 needs to conduct)
MP1 Y A VDD VDD pmos1v W=420n L=100n
MP2 Y B VDD VDD pmos1v W=420n L=100n
MP3 Y C VDD VDD pmos1v W=420n L=100n
MP4 Y D VDD VDD pmos1v W=420n L=100n
* NMOS series pull-down (W=800n=4x to compensate 4 in series)
MN1 Y    A n1  VSS nmos1v W=800n L=100n
MN2 n1   B n2  VSS nmos1v W=800n L=100n
MN3 n2   C n3  VSS nmos1v W=800n L=100n
MN4 n3   D VSS VSS nmos1v W=800n L=100n
.ends NAND4

.subckt DLAT E D Q VDD VSS
* D-latch: transparent when E=1, holds when E=0
* Positive feedback via double-inverter for bistability
* En_b = NOT(E)
MEINV_P En_b E VDD VDD pmos1v W=420n L=100n
MEINV_N En_b E VSS VSS nmos1v W=200n L=100n
* TG1: pass D to X when E=1 (NMOS gate=E, PMOS gate=En_b)
MTG1N X D E   VSS nmos1v W=200n L=100n
MTG1P X D En_b VDD pmos1v W=420n L=100n
* INV1: X -> Qb
MINV1P Qb X VDD VDD pmos1v W=420n L=100n
MINV1N Qb X VSS VSS nmos1v W=200n L=100n
* INV2: Qb -> Q (output)
MINV2P Q Qb VDD VDD pmos1v W=420n L=100n
MINV2N Q Qb VSS VSS nmos1v W=200n L=100n
* TG2: Q -> X when E=0 (hold/bistable feedback)
* NMOS gate=En_b (ON when E=0), PMOS gate=E (ON when E=0)
MTG2N X Q En_b VSS nmos1v W=200n L=100n
MTG2P X Q E   VDD pmos1v W=420n L=100n
.ends DLAT

.subckt mem4 CLK DIN ADDR3 ADDR2 ADDR1 ADDR0 DOUT3 DOUT2 DOUT1 DOUT0 VDD VSS
* 16x4-bit Sigmoid LUT ROM
* DOUT[3] always 0 (all stored values 2-6 have bit3=0)

* === SECTION 1: Address complements ===
XA3b ADDR3 A3b VDD VSS INV
XA2b ADDR2 A2b VDD VSS INV
XA1b ADDR1 A1b VDD VSS INV
XA0b ADDR0 A0b VDD VSS INV

* === SECTION 2: 4-to-16 decoder (NAND4 + INV per wordline) ===
* Wi_b = NAND4 output (active low), Wi = INV(Wi_b) (active high)
XW00N A3b A2b A1b A0b W00b VDD VSS NAND4
XW00I W00b W00 VDD VSS INV
XW01N A3b A2b A1b ADDR0 W01b VDD VSS NAND4
XW01I W01b W01 VDD VSS INV
XW02N A3b A2b ADDR1 A0b W02b VDD VSS NAND4
XW02I W02b W02 VDD VSS INV
XW03N A3b A2b ADDR1 ADDR0 W03b VDD VSS NAND4
XW03I W03b W03 VDD VSS INV
XW04N A3b ADDR2 A1b A0b W04b VDD VSS NAND4
XW04I W04b W04 VDD VSS INV
XW05N A3b ADDR2 A1b ADDR0 W05b VDD VSS NAND4
XW05I W05b W05 VDD VSS INV
XW06N A3b ADDR2 ADDR1 A0b W06b VDD VSS NAND4
XW06I W06b W06 VDD VSS INV
XW07N A3b ADDR2 ADDR1 ADDR0 W07b VDD VSS NAND4
XW07I W07b W07 VDD VSS INV
XW08N ADDR3 A2b A1b A0b W08b VDD VSS NAND4
XW08I W08b W08 VDD VSS INV
XW09N ADDR3 A2b A1b ADDR0 W09b VDD VSS NAND4
XW09I W09b W09 VDD VSS INV
XW10N ADDR3 A2b ADDR1 A0b W10b VDD VSS NAND4
XW10I W10b W10 VDD VSS INV
XW11N ADDR3 A2b ADDR1 ADDR0 W11b VDD VSS NAND4
XW11I W11b W11 VDD VSS INV
XW12N ADDR3 ADDR2 A1b A0b W12b VDD VSS NAND4
XW12I W12b W12 VDD VSS INV
XW13N ADDR3 ADDR2 A1b ADDR0 W13b VDD VSS NAND4
XW13I W13b W13 VDD VSS INV
XW14N ADDR3 ADDR2 ADDR1 A0b W14b VDD VSS NAND4
XW14I W14b W14 VDD VSS INV
XW15N ADDR3 ADDR2 ADDR1 ADDR0 W15b VDD VSS NAND4
XW15I W15b W15 VDD VSS INV

* === SECTION 3: NOR ROM array ===
* Pseudo-NMOS: PMOS pull-up (gate=VSS, always ON, weak: W=200n L=400n)
* ROM NMOS: pull-down cells (W=400n L=100n), gate=wordline
* NOR logic: BL=HIGH when no NMOS conducts (output bit=1)
*            BL=LOW  when NMOS conducts    (output bit=0)

* DOUT[3] = constant 0 (all values 2-6 have MSB=0) — tied to VSS
RDOUT3 DOUT3 VSS 0

* DOUT[2] bitline: pull-up + 6 programmed NMOS
MPBL2 BL2 VSS VDD VDD pmos1v W=200n L=400n  * weak pull-up (gate=VSS=ON)
MBL2N0 BL2 W08 VSS VSS nmos1v W=400n L=100n  * addr=8->val=3or2->bit2=0
MBL2N1 BL2 W09 VSS VSS nmos1v W=400n L=100n  * addr=9->val=3or2->bit2=0
MBL2N2 BL2 W10 VSS VSS nmos1v W=400n L=100n  * addr=10->val=3or2->bit2=0
MBL2N3 BL2 W11 VSS VSS nmos1v W=400n L=100n  * addr=11->val=3or2->bit2=0
MBL2N4 BL2 W12 VSS VSS nmos1v W=400n L=100n  * addr=12->val=3or2->bit2=0
MBL2N5 BL2 W13 VSS VSS nmos1v W=400n L=100n  * addr=13->val=3or2->bit2=0

* DOUT[1] bitline: pull-up + 8 programmed NMOS
MPBL1 BL1 VSS VDD VDD pmos1v W=200n L=400n  * weak pull-up
MBL1N0 BL1 W00 VSS VSS nmos1v W=400n L=100n  * addr=0->val=4or5->bit1=0
MBL1N1 BL1 W01 VSS VSS nmos1v W=400n L=100n  * addr=1->val=4or5->bit1=0
MBL1N2 BL1 W02 VSS VSS nmos1v W=400n L=100n  * addr=2->val=4or5->bit1=0
MBL1N3 BL1 W03 VSS VSS nmos1v W=400n L=100n  * addr=3->val=4or5->bit1=0
MBL1N4 BL1 W04 VSS VSS nmos1v W=400n L=100n  * addr=4->val=4or5->bit1=0
MBL1N5 BL1 W05 VSS VSS nmos1v W=400n L=100n  * addr=5->val=4or5->bit1=0
MBL1N6 BL1 W14 VSS VSS nmos1v W=400n L=100n  * addr=14->val=4or5->bit1=0
MBL1N7 BL1 W15 VSS VSS nmos1v W=400n L=100n  * addr=15->val=4or5->bit1=0

* DOUT[0] bitline: pull-up + 9 programmed NMOS
MPBL0 BL0 VSS VDD VDD pmos1v W=200n L=400n  * weak pull-up
MBL0N0 BL0 W00 VSS VSS nmos1v W=400n L=100n  * addr=0->bit0=0
MBL0N1 BL0 W01 VSS VSS nmos1v W=400n L=100n  * addr=1->bit0=0
MBL0N2 BL0 W02 VSS VSS nmos1v W=400n L=100n  * addr=2->bit0=0
MBL0N3 BL0 W06 VSS VSS nmos1v W=400n L=100n  * addr=6->bit0=0
MBL0N4 BL0 W07 VSS VSS nmos1v W=400n L=100n  * addr=7->bit0=0
MBL0N5 BL0 W08 VSS VSS nmos1v W=400n L=100n  * addr=8->bit0=0
MBL0N6 BL0 W09 VSS VSS nmos1v W=400n L=100n  * addr=9->bit0=0
MBL0N7 BL0 W14 VSS VSS nmos1v W=400n L=100n  * addr=14->bit0=0
MBL0N8 BL0 W15 VSS VSS nmos1v W=400n L=100n  * addr=15->bit0=0

* === SECTION 4: Output register (D-latch with CLK enable) ===
* CLK_EN = CLK AND DIN = INV(NAND2(CLK, DIN))
XCLK_NAND CLK DIN CLK_EN_b VDD VSS NAND2
XCLK_INV  CLK_EN_b CLK_EN VDD VSS INV
* 3 D-latches: transparent when CLK_EN=1 (CLK=1 AND DIN=1)
XDLAT2 CLK_EN BL2 DOUT2 VDD VSS DLAT
XDLAT1 CLK_EN BL1 DOUT1 VDD VSS DLAT
XDLAT0 CLK_EN BL0 DOUT0 VDD VSS DLAT

.ends mem4

* End of mem4.cdl
* Total transistors: ~230
* Breakdown:
*   4 INV (addr complements)  : 4x2  =   8 FETs
*  16 NAND4 (decoder)         : 16x8 = 128 FETs
*  16 INV  (wordline buffer)  : 16x2 =  32 FETs
*   3 PMOS (bitline pull-up)  :         3 FETs
*  23 NMOS (ROM array cells)  :        23 FETs
*   1 NAND2 + 1 INV (CLK_EN) :   4+2 =  6 FETs
*   3 DLAT (output latches)   : 3x10 =  30 FETs
*   Total                     :       230 FETs
