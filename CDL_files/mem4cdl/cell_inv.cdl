**** INV — Basic Inverter ****
* Ports: A(in) Y(out) VDD VSS
* Technology: gpdk090 | nmos1v W=200n L=100n | pmos1v W=420n L=100n

.SUBCKT INV A Y VDD VSS
*.PININFO A:I Y:O VDD:I VSS:I
MP Y A VDD VDD pmos1v W=420n L=100n
MN Y A VSS VSS nmos1v W=200n L=100n
.ENDS INV
