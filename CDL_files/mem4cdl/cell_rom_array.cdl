**** ROM_ARRAY — 16-wordline x 3-bitline NOR ROM ****
* Ports: W00..W15 (wordlines, active HIGH)
*        BL2 BL1 BL0 (bitlines, HIGH=1 LOW=0)
*        VDD VSS
* PMOS pull-up: W=200n L=400n gate=VSS (always ON, weak)
* ROM NMOS   : W=400n L=100n gate=Wi   (pulls BL low when Wi=1)
*
* Sigmoid LUT contents (ADDR -> DOUT[3:2:1:0]):
*  0->4(0100) 1->4  2->4  3->5(0101) 4->5  5->5
*  6->6(0110) 7->6  8->2(0010) 9->2
* 10->3(0011) 11->3 12->3 13->3 14->4 15->4
* DOUT[3]=0 always (not in this module, tied VSS in mem4)
*
* BL HIGH = bit 1 (no NMOS pulls down)
* BL LOW  = bit 0 (NMOS present and wordline active)

.SUBCKT ROM_ARRAY W00 W01 W02 W03 W04 W05 W06 W07
+                 W08 W09 W10 W11 W12 W13 W14 W15
+                 BL2 BL1 BL0 VDD VSS
*.PININFO W00:I W01:I W02:I W03:I W04:I W05:I W06:I W07:I
*.PININFO W08:I W09:I W10:I W11:I W12:I W13:I W14:I W15:I
*.PININFO BL2:O BL1:O BL0:O VDD:I VSS:I

*--- BL2 (DOUT[2]): HIGH for addrs 0-7,14,15 | LOW for addrs 8-13 ---*
MPBL2 BL2 VSS VDD VDD pmos1v W=200n L=400n
MBL2_08 BL2 W08 VSS VSS nmos1v W=400n L=100n
MBL2_09 BL2 W09 VSS VSS nmos1v W=400n L=100n
MBL2_10 BL2 W10 VSS VSS nmos1v W=400n L=100n
MBL2_11 BL2 W11 VSS VSS nmos1v W=400n L=100n
MBL2_12 BL2 W12 VSS VSS nmos1v W=400n L=100n
MBL2_13 BL2 W13 VSS VSS nmos1v W=400n L=100n

*--- BL1 (DOUT[1]): HIGH for addrs 6-13 | LOW for addrs 0-5,14,15 ---*
MPBL1 BL1 VSS VDD VDD pmos1v W=200n L=400n
MBL1_00 BL1 W00 VSS VSS nmos1v W=400n L=100n
MBL1_01 BL1 W01 VSS VSS nmos1v W=400n L=100n
MBL1_02 BL1 W02 VSS VSS nmos1v W=400n L=100n
MBL1_03 BL1 W03 VSS VSS nmos1v W=400n L=100n
MBL1_04 BL1 W04 VSS VSS nmos1v W=400n L=100n
MBL1_05 BL1 W05 VSS VSS nmos1v W=400n L=100n
MBL1_14 BL1 W14 VSS VSS nmos1v W=400n L=100n
MBL1_15 BL1 W15 VSS VSS nmos1v W=400n L=100n

*--- BL0 (DOUT[0]): HIGH for addrs 3-5,10-13 | LOW for addrs 0-2,6-9,14,15 ---*
MPBL0 BL0 VSS VDD VDD pmos1v W=200n L=400n
MBL0_00 BL0 W00 VSS VSS nmos1v W=400n L=100n
MBL0_01 BL0 W01 VSS VSS nmos1v W=400n L=100n
MBL0_02 BL0 W02 VSS VSS nmos1v W=400n L=100n
MBL0_06 BL0 W06 VSS VSS nmos1v W=400n L=100n
MBL0_07 BL0 W07 VSS VSS nmos1v W=400n L=100n
MBL0_08 BL0 W08 VSS VSS nmos1v W=400n L=100n
MBL0_09 BL0 W09 VSS VSS nmos1v W=400n L=100n
MBL0_14 BL0 W14 VSS VSS nmos1v W=400n L=100n
MBL0_15 BL0 W15 VSS VSS nmos1v W=400n L=100n

.ENDS ROM_ARRAY
