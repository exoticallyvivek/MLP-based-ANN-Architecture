**** NAND2 — 2-Input NAND Gate ****
* Ports: A B(in) Y(out) VDD VSS
* Y = NOT(A AND B)

.SUBCKT NAND2 A B Y VDD VSS
*.PININFO A:I B:I Y:O VDD:I VSS:I
MP1 Y A VDD VDD pmos1v W=420n L=100n
MP2 Y B VDD VDD pmos1v W=420n L=100n
MN1 Y  A net1 VSS nmos1v W=200n L=100n
MN2 net1 B VSS VSS nmos1v W=200n L=100n
.ENDS NAND2
